* NGSPICE file created from async_fifo.ext - technology: sky130A

* Black-box entry subcircuit for sky130_fd_sc_hd__decap_3 abstract view
.subckt sky130_fd_sc_hd__decap_3 VGND VNB VPB VPWR
.ends

* Black-box entry subcircuit for sky130_fd_sc_hd__mux2_1 abstract view
.subckt sky130_fd_sc_hd__mux2_1 A0 A1 S VGND VNB VPB VPWR X
.ends

* Black-box entry subcircuit for sky130_fd_sc_hd__xor2_1 abstract view
.subckt sky130_fd_sc_hd__xor2_1 A B VGND VNB VPB VPWR X
.ends

* Black-box entry subcircuit for sky130_fd_sc_hd__a21o_1 abstract view
.subckt sky130_fd_sc_hd__a21o_1 A1 A2 B1 VGND VNB VPB VPWR X
.ends

* Black-box entry subcircuit for sky130_ef_sc_hd__decap_12 abstract view
.subckt sky130_ef_sc_hd__decap_12 VPWR VGND VPB VNB
.ends

* Black-box entry subcircuit for sky130_fd_sc_hd__decap_4 abstract view
.subckt sky130_fd_sc_hd__decap_4 VGND VNB VPB VPWR
.ends

* Black-box entry subcircuit for sky130_fd_sc_hd__fill_1 abstract view
.subckt sky130_fd_sc_hd__fill_1 VGND VNB VPB VPWR
.ends

* Black-box entry subcircuit for sky130_fd_sc_hd__or2_1 abstract view
.subckt sky130_fd_sc_hd__or2_1 A B VGND VNB VPB VPWR X
.ends

* Black-box entry subcircuit for sky130_fd_sc_hd__xnor2_1 abstract view
.subckt sky130_fd_sc_hd__xnor2_1 A B VGND VNB VPB VPWR Y
.ends

* Black-box entry subcircuit for sky130_fd_sc_hd__tapvpwrvgnd_1 abstract view
.subckt sky130_fd_sc_hd__tapvpwrvgnd_1 VGND VPWR
.ends

* Black-box entry subcircuit for sky130_fd_sc_hd__decap_8 abstract view
.subckt sky130_fd_sc_hd__decap_8 VGND VNB VPB VPWR
.ends

* Black-box entry subcircuit for sky130_fd_sc_hd__xor2_2 abstract view
.subckt sky130_fd_sc_hd__xor2_2 A B VGND VNB VPB VPWR X
.ends

* Black-box entry subcircuit for sky130_fd_sc_hd__dfxtp_1 abstract view
.subckt sky130_fd_sc_hd__dfxtp_1 CLK D VGND VNB VPB VPWR Q
.ends

* Black-box entry subcircuit for sky130_fd_sc_hd__dlygate4sd3_1 abstract view
.subckt sky130_fd_sc_hd__dlygate4sd3_1 A VGND VNB VPB VPWR X
.ends

* Black-box entry subcircuit for sky130_fd_sc_hd__decap_6 abstract view
.subckt sky130_fd_sc_hd__decap_6 VGND VNB VPB VPWR
.ends

* Black-box entry subcircuit for sky130_fd_sc_hd__buf_2 abstract view
.subckt sky130_fd_sc_hd__buf_2 A VGND VNB VPB VPWR X
.ends

* Black-box entry subcircuit for sky130_fd_sc_hd__fill_2 abstract view
.subckt sky130_fd_sc_hd__fill_2 VGND VNB VPB VPWR
.ends

* Black-box entry subcircuit for sky130_fd_sc_hd__nand3_1 abstract view
.subckt sky130_fd_sc_hd__nand3_1 A B C VGND VNB VPB VPWR Y
.ends

* Black-box entry subcircuit for sky130_fd_sc_hd__nor2_1 abstract view
.subckt sky130_fd_sc_hd__nor2_1 A B VGND VNB VPB VPWR Y
.ends

* Black-box entry subcircuit for sky130_fd_sc_hd__xnor2_2 abstract view
.subckt sky130_fd_sc_hd__xnor2_2 A B VGND VNB VPB VPWR Y
.ends

* Black-box entry subcircuit for sky130_fd_sc_hd__a211o_1 abstract view
.subckt sky130_fd_sc_hd__a211o_1 A1 A2 B1 C1 VGND VNB VPB VPWR X
.ends

* Black-box entry subcircuit for sky130_fd_sc_hd__and2_1 abstract view
.subckt sky130_fd_sc_hd__and2_1 A B VGND VNB VPB VPWR X
.ends

* Black-box entry subcircuit for sky130_fd_sc_hd__clkbuf_8 abstract view
.subckt sky130_fd_sc_hd__clkbuf_8 A VGND VNB VPB VPWR X
.ends

* Black-box entry subcircuit for sky130_fd_sc_hd__a32o_1 abstract view
.subckt sky130_fd_sc_hd__a32o_1 A1 A2 A3 B1 B2 VGND VNB VPB VPWR X
.ends

* Black-box entry subcircuit for sky130_fd_sc_hd__inv_2 abstract view
.subckt sky130_fd_sc_hd__inv_2 A VGND VNB VPB VPWR Y
.ends

* Black-box entry subcircuit for sky130_fd_sc_hd__dfrtp_1 abstract view
.subckt sky130_fd_sc_hd__dfrtp_1 CLK D RESET_B VGND VNB VPB VPWR Q
.ends

* Black-box entry subcircuit for sky130_fd_sc_hd__nand2_1 abstract view
.subckt sky130_fd_sc_hd__nand2_1 A B VGND VNB VPB VPWR Y
.ends

* Black-box entry subcircuit for sky130_fd_sc_hd__clkbuf_4 abstract view
.subckt sky130_fd_sc_hd__clkbuf_4 A VGND VNB VPB VPWR X
.ends

* Black-box entry subcircuit for sky130_fd_sc_hd__and3_1 abstract view
.subckt sky130_fd_sc_hd__and3_1 A B C VGND VNB VPB VPWR X
.ends

* Black-box entry subcircuit for sky130_fd_sc_hd__mux4_1 abstract view
.subckt sky130_fd_sc_hd__mux4_1 A0 A1 A2 A3 S0 S1 VGND VNB VPB VPWR X
.ends

* Black-box entry subcircuit for sky130_fd_sc_hd__buf_1 abstract view
.subckt sky130_fd_sc_hd__buf_1 A VGND VNB VPB VPWR X
.ends

* Black-box entry subcircuit for sky130_fd_sc_hd__nor2_4 abstract view
.subckt sky130_fd_sc_hd__nor2_4 A B VGND VNB VPB VPWR Y
.ends

* Black-box entry subcircuit for sky130_fd_sc_hd__nand2_2 abstract view
.subckt sky130_fd_sc_hd__nand2_2 A B VGND VNB VPB VPWR Y
.ends

* Black-box entry subcircuit for sky130_fd_sc_hd__clkbuf_2 abstract view
.subckt sky130_fd_sc_hd__clkbuf_2 A VGND VNB VPB VPWR X
.ends

* Black-box entry subcircuit for sky130_fd_sc_hd__clkinv_4 abstract view
.subckt sky130_fd_sc_hd__clkinv_4 A VGND VNB VPB VPWR Y
.ends

* Black-box entry subcircuit for sky130_fd_sc_hd__buf_4 abstract view
.subckt sky130_fd_sc_hd__buf_4 A VGND VNB VPB VPWR X
.ends

* Black-box entry subcircuit for sky130_fd_sc_hd__inv_6 abstract view
.subckt sky130_fd_sc_hd__inv_6 A VGND VNB VPB VPWR Y
.ends

* Black-box entry subcircuit for sky130_fd_sc_hd__or3b_4 abstract view
.subckt sky130_fd_sc_hd__or3b_4 A B C_N VGND VNB VPB VPWR X
.ends

* Black-box entry subcircuit for sky130_fd_sc_hd__dfrtp_2 abstract view
.subckt sky130_fd_sc_hd__dfrtp_2 CLK D RESET_B VGND VNB VPB VPWR Q
.ends

* Black-box entry subcircuit for sky130_fd_sc_hd__and2b_1 abstract view
.subckt sky130_fd_sc_hd__and2b_1 A_N B VGND VNB VPB VPWR X
.ends

* Black-box entry subcircuit for sky130_fd_sc_hd__bufinv_16 abstract view
.subckt sky130_fd_sc_hd__bufinv_16 A VGND VNB VPB VPWR Y
.ends

* Black-box entry subcircuit for sky130_fd_sc_hd__a21oi_1 abstract view
.subckt sky130_fd_sc_hd__a21oi_1 A1 A2 B1 VGND VNB VPB VPWR Y
.ends

* Black-box entry subcircuit for sky130_fd_sc_hd__inv_8 abstract view
.subckt sky130_fd_sc_hd__inv_8 A VGND VNB VPB VPWR Y
.ends

* Black-box entry subcircuit for sky130_fd_sc_hd__clkinvlp_4 abstract view
.subckt sky130_fd_sc_hd__clkinvlp_4 A VGND VNB VPB VPWR Y
.ends

* Black-box entry subcircuit for sky130_fd_sc_hd__clkbuf_1 abstract view
.subckt sky130_fd_sc_hd__clkbuf_1 A VGND VNB VPB VPWR X
.ends

* Black-box entry subcircuit for sky130_fd_sc_hd__nand3b_4 abstract view
.subckt sky130_fd_sc_hd__nand3b_4 A_N B C VGND VNB VPB VPWR Y
.ends

* Black-box entry subcircuit for sky130_fd_sc_hd__o21ai_1 abstract view
.subckt sky130_fd_sc_hd__o21ai_1 A1 A2 B1 VGND VNB VPB VPWR Y
.ends

* Black-box entry subcircuit for sky130_fd_sc_hd__o21ai_2 abstract view
.subckt sky130_fd_sc_hd__o21ai_2 A1 A2 B1 VGND VNB VPB VPWR Y
.ends

* Black-box entry subcircuit for sky130_fd_sc_hd__dfstp_1 abstract view
.subckt sky130_fd_sc_hd__dfstp_1 CLK D SET_B VGND VNB VPB VPWR Q
.ends

* Black-box entry subcircuit for sky130_fd_sc_hd__nand2b_2 abstract view
.subckt sky130_fd_sc_hd__nand2b_2 A_N B VGND VNB VPB VPWR Y
.ends

* Black-box entry subcircuit for sky130_fd_sc_hd__o31a_1 abstract view
.subckt sky130_fd_sc_hd__o31a_1 A1 A2 A3 B1 VGND VNB VPB VPWR X
.ends

* Black-box entry subcircuit for sky130_fd_sc_hd__o21ba_1 abstract view
.subckt sky130_fd_sc_hd__o21ba_1 A1 A2 B1_N VGND VNB VPB VPWR X
.ends

* Black-box entry subcircuit for sky130_fd_sc_hd__dfrtp_4 abstract view
.subckt sky130_fd_sc_hd__dfrtp_4 CLK D RESET_B VGND VNB VPB VPWR Q
.ends

* Black-box entry subcircuit for sky130_fd_sc_hd__o21a_1 abstract view
.subckt sky130_fd_sc_hd__o21a_1 A1 A2 B1 VGND VNB VPB VPWR X
.ends

* Black-box entry subcircuit for sky130_fd_sc_hd__a2bb2o_1 abstract view
.subckt sky130_fd_sc_hd__a2bb2o_1 A1_N A2_N B1 B2 VGND VNB VPB VPWR X
.ends

* Black-box entry subcircuit for sky130_fd_sc_hd__or3_1 abstract view
.subckt sky130_fd_sc_hd__or3_1 A B C VGND VNB VPB VPWR X
.ends

* Black-box entry subcircuit for sky130_fd_sc_hd__o221a_1 abstract view
.subckt sky130_fd_sc_hd__o221a_1 A1 A2 B1 B2 C1 VGND VNB VPB VPWR X
.ends

* Black-box entry subcircuit for sky130_fd_sc_hd__and2b_2 abstract view
.subckt sky130_fd_sc_hd__and2b_2 A_N B VGND VNB VPB VPWR X
.ends

* Black-box entry subcircuit for sky130_fd_sc_hd__or4b_1 abstract view
.subckt sky130_fd_sc_hd__or4b_1 A B C D_N VGND VNB VPB VPWR X
.ends

* Black-box entry subcircuit for sky130_fd_sc_hd__o211ai_1 abstract view
.subckt sky130_fd_sc_hd__o211ai_1 A1 A2 B1 C1 VGND VNB VPB VPWR Y
.ends

* Black-box entry subcircuit for sky130_fd_sc_hd__clkbuf_16 abstract view
.subckt sky130_fd_sc_hd__clkbuf_16 A VGND VNB VPB VPWR X
.ends

* Black-box entry subcircuit for sky130_fd_sc_hd__nand2_4 abstract view
.subckt sky130_fd_sc_hd__nand2_4 A B VGND VNB VPB VPWR Y
.ends

* Black-box entry subcircuit for sky130_fd_sc_hd__nand2b_4 abstract view
.subckt sky130_fd_sc_hd__nand2b_4 A_N B VGND VNB VPB VPWR Y
.ends

* Black-box entry subcircuit for sky130_fd_sc_hd__or2_2 abstract view
.subckt sky130_fd_sc_hd__or2_2 A B VGND VNB VPB VPWR X
.ends

* Black-box entry subcircuit for sky130_fd_sc_hd__nor3b_1 abstract view
.subckt sky130_fd_sc_hd__nor3b_1 A B C_N VGND VNB VPB VPWR Y
.ends

* Black-box entry subcircuit for sky130_fd_sc_hd__and3_2 abstract view
.subckt sky130_fd_sc_hd__and3_2 A B C VGND VNB VPB VPWR X
.ends

* Black-box entry subcircuit for sky130_fd_sc_hd__a21bo_1 abstract view
.subckt sky130_fd_sc_hd__a21bo_1 A1 A2 B1_N VGND VNB VPB VPWR X
.ends

* Black-box entry subcircuit for sky130_fd_sc_hd__and3b_1 abstract view
.subckt sky130_fd_sc_hd__and3b_1 A_N B C VGND VNB VPB VPWR X
.ends

.subckt async_fifo VGND VPWR aempty aempty_threshold[0] aempty_threshold[1] aempty_threshold[2]
+ aempty_threshold[3] aempty_threshold[4] afull afull_threshold[0] afull_threshold[1]
+ afull_threshold[2] afull_threshold[3] afull_threshold[4] arst_n empty full rd_clk
+ rd_data[0] rd_data[1] rd_data[2] rd_data[3] rd_data[4] rd_data[5] rd_data[6] rd_data[7]
+ rd_en wr_clk wr_data[0] wr_data[1] wr_data[2] wr_data[3] wr_data[4] wr_data[5] wr_data[6]
+ wr_data[7] wr_en
XFILLER_45_225 VGND VGND VPWR VPWR sky130_fd_sc_hd__decap_3
X_501_ net117 net53 _287_ VGND VGND VPWR VPWR _022_ sky130_fd_sc_hd__mux2_1
X_432_ rd_bin\[4\] _235_ VGND VGND VPWR VPWR rd_bin_next\[4\] sky130_fd_sc_hd__xor2_1
XFILLER_26_85 VGND VGND VPWR VPWR sky130_fd_sc_hd__decap_3
X_363_ _176_ _189_ _190_ VGND VGND VPWR VPWR _193_ sky130_fd_sc_hd__a21o_1
XFILLER_3_78 VPWR VGND VPWR VGND sky130_ef_sc_hd__decap_12
XFILLER_42_206 VGND VGND VPWR VPWR sky130_fd_sc_hd__decap_4
XFILLER_27_225 VGND VGND VPWR VPWR sky130_fd_sc_hd__decap_4
XFILLER_50_261 VGND VGND VPWR VPWR sky130_fd_sc_hd__fill_1
XFILLER_10_169 VGND VGND VPWR VPWR sky130_fd_sc_hd__fill_1
XFILLER_37_51 VGND VGND VPWR VPWR sky130_fd_sc_hd__decap_4
X_346_ net39 _175_ VGND VGND VPWR VPWR _176_ sky130_fd_sc_hd__or2_1
X_415_ net41 _229_ VGND VGND VPWR VPWR rd_gray_next\[1\] sky130_fd_sc_hd__xnor2_1
XTAP_TAPCELL_ROW_11_164 VGND VPWR sky130_fd_sc_hd__tapvpwrvgnd_1
XTAP_TAPCELL_ROW_34_278 VGND VPWR sky130_fd_sc_hd__tapvpwrvgnd_1
XTAP_TAPCELL_ROW_2_121 VGND VPWR sky130_fd_sc_hd__tapvpwrvgnd_1
XFILLER_23_272 VGND VGND VPWR VPWR sky130_fd_sc_hd__decap_8
XTAP_TAPCELL_ROW_25_234 VGND VPWR sky130_fd_sc_hd__tapvpwrvgnd_1
XFILLER_2_165 VGND VGND VPWR VPWR sky130_fd_sc_hd__fill_1
XTAP_TAPCELL_ROW_48_348 VGND VPWR sky130_fd_sc_hd__tapvpwrvgnd_1
XFILLER_48_83 VGND VGND VPWR VPWR sky130_fd_sc_hd__fill_1
XFILLER_0_57 VGND VGND VPWR VPWR sky130_fd_sc_hd__decap_8
X_329_ wr_bin\[4\] rd_bin_sync\[4\] VGND VGND VPWR VPWR _160_ sky130_fd_sc_hd__xor2_2
XFILLER_50_3 VPWR VGND VPWR VGND sky130_ef_sc_hd__decap_12
XTAP_TAPCELL_ROW_39_304 VGND VPWR sky130_fd_sc_hd__tapvpwrvgnd_1
XFILLER_20_253 VPWR VGND VPWR VGND sky130_ef_sc_hd__decap_12
XFILLER_47_128 VGND VGND VPWR VPWR sky130_fd_sc_hd__fill_1
XFILLER_43_301 VGND VGND VPWR VPWR sky130_fd_sc_hd__fill_1
X_680_ clknet_4_7_0_wr_clk _048_ VGND VGND VPWR VPWR mem\[10\]\[0\] sky130_fd_sc_hd__dfxtp_1
XFILLER_34_85 VPWR VGND VPWR VGND sky130_ef_sc_hd__decap_12
XFILLER_7_279 VGND VGND VPWR VPWR sky130_fd_sc_hd__fill_1
XFILLER_46_150 VPWR VGND VPWR VGND sky130_ef_sc_hd__decap_12
XFILLER_34_301 VGND VGND VPWR VPWR sky130_fd_sc_hd__fill_1
XTAP_TAPCELL_ROW_50_365 VGND VPWR sky130_fd_sc_hd__tapvpwrvgnd_1
XFILLER_20_65 VGND VGND VPWR VPWR sky130_fd_sc_hd__fill_1
Xhold41 mem\[13\]\[6\] VGND VGND VPWR VPWR net117 sky130_fd_sc_hd__dlygate4sd3_1
X_732_ clknet_4_10_0_wr_clk _100_ VGND VGND VPWR VPWR mem\[3\]\[4\] sky130_fd_sc_hd__dfxtp_1
Xhold74 mem\[1\]\[5\] VGND VGND VPWR VPWR net150 sky130_fd_sc_hd__dlygate4sd3_1
Xhold63 mem\[14\]\[3\] VGND VGND VPWR VPWR net139 sky130_fd_sc_hd__dlygate4sd3_1
X_801_ clknet_4_1_0_wr_clk _127_ VGND VGND VPWR VPWR mem\[15\]\[7\] sky130_fd_sc_hd__dfxtp_1
Xhold52 mem\[6\]\[2\] VGND VGND VPWR VPWR net128 sky130_fd_sc_hd__dlygate4sd3_1
Xhold30 mem\[2\]\[0\] VGND VGND VPWR VPWR net106 sky130_fd_sc_hd__dlygate4sd3_1
Xhold85 mem\[3\]\[6\] VGND VGND VPWR VPWR net161 sky130_fd_sc_hd__dlygate4sd3_1
Xhold96 mem\[1\]\[0\] VGND VGND VPWR VPWR net172 sky130_fd_sc_hd__dlygate4sd3_1
X_594_ net56 net170 _301_ VGND VGND VPWR VPWR _101_ sky130_fd_sc_hd__mux2_1
X_663_ clknet_4_1_0_wr_clk _031_ VGND VGND VPWR VPWR mem\[12\]\[7\] sky130_fd_sc_hd__dfxtp_1
XFILLER_3_293 VGND VGND VPWR VPWR sky130_fd_sc_hd__decap_8
XFILLER_13_3 VPWR VGND VPWR VGND sky130_ef_sc_hd__decap_12
XFILLER_34_175 VGND VGND VPWR VPWR sky130_fd_sc_hd__decap_4
XFILLER_40_134 VGND VGND VPWR VPWR sky130_fd_sc_hd__decap_6
Xoutput31 net31 VGND VGND VPWR VPWR rd_data[4] sky130_fd_sc_hd__buf_2
X_715_ clknet_4_2_0_wr_clk _083_ VGND VGND VPWR VPWR mem\[6\]\[3\] sky130_fd_sc_hd__dfxtp_1
X_646_ clknet_4_5_0_wr_clk _014_ VGND VGND VPWR VPWR mem\[14\]\[6\] sky130_fd_sc_hd__dfxtp_1
X_577_ net143 net53 _299_ VGND VGND VPWR VPWR _086_ sky130_fd_sc_hd__mux2_1
XFILLER_16_153 VGND VGND VPWR VPWR sky130_fd_sc_hd__decap_6
XFILLER_31_134 VGND VGND VPWR VPWR sky130_fd_sc_hd__decap_4
XFILLER_31_167 VGND VGND VPWR VPWR sky130_fd_sc_hd__fill_1
XFILLER_39_278 VGND VGND VPWR VPWR sky130_fd_sc_hd__fill_2
XTAP_TAPCELL_ROW_17_192 VGND VPWR sky130_fd_sc_hd__tapvpwrvgnd_1
XFILLER_45_204 VPWR VGND VPWR VGND sky130_ef_sc_hd__decap_12
X_500_ net116 net55 _287_ VGND VGND VPWR VPWR _021_ sky130_fd_sc_hd__mux2_1
X_362_ _176_ _189_ _190_ VGND VGND VPWR VPWR _192_ sky130_fd_sc_hd__nand3_1
X_431_ _235_ _239_ VGND VGND VPWR VPWR rd_bin_next\[3\] sky130_fd_sc_hd__nor2_1
XFILLER_26_20 VGND VGND VPWR VPWR sky130_fd_sc_hd__decap_8
XFILLER_26_53 VGND VGND VPWR VPWR sky130_fd_sc_hd__fill_1
XFILLER_9_149 VPWR VGND VPWR VGND sky130_ef_sc_hd__decap_12
XFILLER_3_35 VGND VGND VPWR VPWR sky130_fd_sc_hd__fill_1
X_629_ net145 net55 _304_ VGND VGND VPWR VPWR _133_ sky130_fd_sc_hd__mux2_1
XFILLER_8_193 VGND VGND VPWR VPWR sky130_fd_sc_hd__decap_3
XFILLER_50_251 VGND VGND VPWR VPWR sky130_fd_sc_hd__fill_1
XFILLER_35_281 VGND VGND VPWR VPWR sky130_fd_sc_hd__decap_6
XFILLER_35_270 VGND VGND VPWR VPWR sky130_fd_sc_hd__decap_8
X_345_ wr_gray_sync2\[3\] wr_bin_sync\[4\] VGND VGND VPWR VPWR _175_ sky130_fd_sc_hd__xnor2_2
X_414_ _231_ _232_ VGND VGND VPWR VPWR rd_bin_next\[2\] sky130_fd_sc_hd__nor2_1
XFILLER_45_6 VPWR VGND VPWR VGND sky130_ef_sc_hd__decap_12
XTAP_TAPCELL_ROW_11_165 VGND VPWR sky130_fd_sc_hd__tapvpwrvgnd_1
XFILLER_32_251 VGND VGND VPWR VPWR sky130_fd_sc_hd__fill_1
XTAP_TAPCELL_ROW_34_279 VGND VPWR sky130_fd_sc_hd__tapvpwrvgnd_1
XPHY_EDGE_ROW_12_Right_12 VGND VGND VPWR VPWR sky130_fd_sc_hd__decap_3
XPHY_EDGE_ROW_21_Right_21 VGND VGND VPWR VPWR sky130_fd_sc_hd__decap_3
XFILLER_23_251 VGND VGND VPWR VPWR sky130_fd_sc_hd__fill_1
XTAP_TAPCELL_ROW_25_235 VGND VPWR sky130_fd_sc_hd__tapvpwrvgnd_1
XPHY_EDGE_ROW_30_Right_30 VGND VGND VPWR VPWR sky130_fd_sc_hd__decap_3
XTAP_TAPCELL_ROW_48_349 VGND VPWR sky130_fd_sc_hd__tapvpwrvgnd_1
XFILLER_0_69 VPWR VGND VPWR VGND sky130_ef_sc_hd__decap_12
X_328_ _149_ _157_ _158_ _146_ VGND VGND VPWR VPWR _159_ sky130_fd_sc_hd__a211o_1
XFILLER_9_67 VGND VGND VPWR VPWR sky130_fd_sc_hd__decap_3
XFILLER_9_78 VPWR VGND VPWR VGND sky130_ef_sc_hd__decap_12
XFILLER_14_251 VGND VGND VPWR VPWR sky130_fd_sc_hd__fill_1
XFILLER_43_3 VGND VGND VPWR VPWR sky130_fd_sc_hd__decap_8
XFILLER_49_181 VPWR VGND VPWR VGND sky130_ef_sc_hd__decap_12
XTAP_TAPCELL_ROW_39_305 VGND VPWR sky130_fd_sc_hd__tapvpwrvgnd_1
XFILLER_20_265 VPWR VGND VPWR VGND sky130_ef_sc_hd__decap_12
XTAP_TAPCELL_ROW_30_260 VGND VPWR sky130_fd_sc_hd__tapvpwrvgnd_1
XPHY_EDGE_ROW_8_Left_59 VGND VGND VPWR VPWR sky130_fd_sc_hd__decap_3
XFILLER_18_21 VGND VGND VPWR VPWR sky130_fd_sc_hd__decap_6
XFILLER_50_41 VPWR VGND VPWR VGND sky130_ef_sc_hd__decap_12
XFILLER_7_225 VPWR VGND VPWR VGND sky130_ef_sc_hd__decap_12
XFILLER_34_97 VGND VGND VPWR VPWR sky130_fd_sc_hd__decap_4
XFILLER_50_85 VPWR VGND VPWR VGND sky130_ef_sc_hd__decap_12
XFILLER_46_195 VGND VGND VPWR VPWR sky130_fd_sc_hd__fill_1
XFILLER_46_162 VPWR VGND VPWR VGND sky130_ef_sc_hd__decap_12
XTAP_TAPCELL_ROW_44_330 VGND VPWR sky130_fd_sc_hd__tapvpwrvgnd_1
XTAP_TAPCELL_ROW_50_366 VGND VPWR sky130_fd_sc_hd__tapvpwrvgnd_1
XFILLER_20_22 VGND VGND VPWR VPWR sky130_fd_sc_hd__decap_6
X_662_ clknet_4_5_0_wr_clk _030_ VGND VGND VPWR VPWR mem\[12\]\[6\] sky130_fd_sc_hd__dfxtp_1
X_800_ clknet_4_5_0_wr_clk _126_ VGND VGND VPWR VPWR mem\[15\]\[6\] sky130_fd_sc_hd__dfxtp_1
Xhold42 mem\[6\]\[0\] VGND VGND VPWR VPWR net118 sky130_fd_sc_hd__dlygate4sd3_1
Xhold31 mem\[4\]\[6\] VGND VGND VPWR VPWR net107 sky130_fd_sc_hd__dlygate4sd3_1
Xhold97 mem\[3\]\[0\] VGND VGND VPWR VPWR net173 sky130_fd_sc_hd__dlygate4sd3_1
Xhold20 mem\[0\]\[6\] VGND VGND VPWR VPWR net96 sky130_fd_sc_hd__dlygate4sd3_1
X_731_ clknet_4_2_0_wr_clk _099_ VGND VGND VPWR VPWR mem\[3\]\[3\] sky130_fd_sc_hd__dfxtp_1
Xhold64 mem\[6\]\[4\] VGND VGND VPWR VPWR net140 sky130_fd_sc_hd__dlygate4sd3_1
Xhold75 mem\[15\]\[3\] VGND VGND VPWR VPWR net151 sky130_fd_sc_hd__dlygate4sd3_1
Xhold86 mem\[9\]\[1\] VGND VGND VPWR VPWR net162 sky130_fd_sc_hd__dlygate4sd3_1
Xhold53 mem\[4\]\[2\] VGND VGND VPWR VPWR net129 sky130_fd_sc_hd__dlygate4sd3_1
XFILLER_45_63 VGND VGND VPWR VPWR sky130_fd_sc_hd__fill_1
XFILLER_45_30 VGND VGND VPWR VPWR sky130_fd_sc_hd__decap_8
X_593_ net57 net190 _301_ VGND VGND VPWR VPWR _100_ sky130_fd_sc_hd__mux2_1
XFILLER_28_195 VGND VGND VPWR VPWR sky130_fd_sc_hd__fill_1
XFILLER_3_261 VPWR VGND VPWR VGND sky130_ef_sc_hd__decap_12
XPHY_EDGE_ROW_6_Right_6 VGND VGND VPWR VPWR sky130_fd_sc_hd__decap_3
XFILLER_25_110 VGND VGND VPWR VPWR sky130_fd_sc_hd__fill_2
Xoutput32 net32 VGND VGND VPWR VPWR rd_data[5] sky130_fd_sc_hd__buf_2
XFILLER_0_253 VPWR VGND VPWR VGND sky130_ef_sc_hd__decap_12
X_645_ clknet_4_0_0_wr_clk _013_ VGND VGND VPWR VPWR mem\[14\]\[5\] sky130_fd_sc_hd__dfxtp_1
X_714_ clknet_4_4_0_wr_clk _082_ VGND VGND VPWR VPWR mem\[6\]\[2\] sky130_fd_sc_hd__dfxtp_1
X_576_ net123 net55 _299_ VGND VGND VPWR VPWR _085_ sky130_fd_sc_hd__mux2_1
XFILLER_31_146 VGND VGND VPWR VPWR sky130_fd_sc_hd__fill_1
XTAP_TAPCELL_ROW_17_193 VGND VPWR sky130_fd_sc_hd__tapvpwrvgnd_1
XFILLER_30_190 VGND VGND VPWR VPWR sky130_fd_sc_hd__decap_6
XFILLER_45_216 VGND VGND VPWR VPWR sky130_fd_sc_hd__decap_8
XPHY_EDGE_ROW_37_Left_88 VGND VGND VPWR VPWR sky130_fd_sc_hd__decap_3
X_430_ wr_bin\[4\] net35 VGND VGND VPWR VPWR wr_bin_next\[4\] sky130_fd_sc_hd__xnor2_1
XFILLER_13_113 VGND VGND VPWR VPWR sky130_fd_sc_hd__fill_2
X_361_ wr_bin_sync\[4\] rd_bin\[4\] VGND VGND VPWR VPWR _191_ sky130_fd_sc_hd__xnor2_1
XFILLER_5_301 VGND VGND VPWR VPWR sky130_fd_sc_hd__fill_1
XTAP_TAPCELL_ROW_8_150 VGND VPWR sky130_fd_sc_hd__tapvpwrvgnd_1
XFILLER_44_271 VGND VGND VPWR VPWR sky130_fd_sc_hd__decap_8
XFILLER_44_260 VGND VGND VPWR VPWR sky130_fd_sc_hd__fill_1
X_628_ net160 net57 _304_ VGND VGND VPWR VPWR _132_ sky130_fd_sc_hd__mux2_1
X_559_ net133 net51 _296_ VGND VGND VPWR VPWR _071_ sky130_fd_sc_hd__mux2_1
XFILLER_10_116 VPWR VGND VPWR VGND sky130_ef_sc_hd__decap_12
XFILLER_6_109 VGND VGND VPWR VPWR sky130_fd_sc_hd__fill_1
XFILLER_12_45 VGND VGND VPWR VPWR sky130_fd_sc_hd__decap_6
XFILLER_18_205 VGND VGND VPWR VPWR sky130_fd_sc_hd__decap_8
X_413_ net40 _230_ VGND VGND VPWR VPWR _232_ sky130_fd_sc_hd__and2_1
X_344_ _163_ _174_ VGND VGND VPWR VPWR afull_next sky130_fd_sc_hd__and2_1
XTAP_TAPCELL_ROW_11_166 VGND VPWR sky130_fd_sc_hd__tapvpwrvgnd_1
XFILLER_15_219 VGND VGND VPWR VPWR sky130_fd_sc_hd__decap_4
XFILLER_23_55 VGND VGND VPWR VPWR sky130_fd_sc_hd__fill_1
XTAP_TAPCELL_ROW_25_236 VGND VPWR sky130_fd_sc_hd__tapvpwrvgnd_1
XFILLER_3_3 VPWR VGND VPWR VGND sky130_ef_sc_hd__decap_12
XFILLER_48_85 VPWR VGND VPWR VGND sky130_ef_sc_hd__decap_12
XFILLER_48_41 VPWR VGND VPWR VGND sky130_ef_sc_hd__decap_12
XFILLER_0_15 VGND VGND VPWR VPWR sky130_fd_sc_hd__decap_8
X_327_ wr_bin\[3\] _145_ VGND VGND VPWR VPWR _158_ sky130_fd_sc_hd__nor2_1
XFILLER_9_57 VGND VGND VPWR VPWR sky130_fd_sc_hd__decap_6
XFILLER_36_3 VGND VGND VPWR VPWR sky130_fd_sc_hd__fill_2
XPHY_EDGE_ROW_24_Left_75 VGND VGND VPWR VPWR sky130_fd_sc_hd__decap_3
XFILLER_49_193 VPWR VGND VPWR VGND sky130_ef_sc_hd__decap_12
XTAP_TAPCELL_ROW_39_306 VGND VPWR sky130_fd_sc_hd__tapvpwrvgnd_1
XTAP_TAPCELL_ROW_22_217 VGND VPWR sky130_fd_sc_hd__tapvpwrvgnd_1
Xclkbuf_4_13_0_wr_clk clknet_0_wr_clk VGND VGND VPWR VPWR clknet_4_13_0_wr_clk sky130_fd_sc_hd__clkbuf_8
XFILLER_20_277 VGND VGND VPWR VPWR sky130_fd_sc_hd__decap_4
XFILLER_20_288 VGND VGND VPWR VPWR sky130_fd_sc_hd__decap_8
XTAP_TAPCELL_ROW_30_261 VGND VPWR sky130_fd_sc_hd__tapvpwrvgnd_1
XFILLER_28_300 VGND VGND VPWR VPWR sky130_fd_sc_hd__fill_2
XFILLER_34_43 VGND VGND VPWR VPWR sky130_fd_sc_hd__fill_1
XFILLER_50_53 VGND VGND VPWR VPWR sky130_fd_sc_hd__decap_3
XFILLER_7_237 VPWR VGND VPWR VGND sky130_ef_sc_hd__decap_12
XFILLER_11_288 VGND VGND VPWR VPWR sky130_fd_sc_hd__decap_8
XFILLER_50_97 VPWR VGND VPWR VGND sky130_ef_sc_hd__decap_12
XFILLER_46_174 VGND VGND VPWR VPWR sky130_fd_sc_hd__decap_3
XTAP_TAPCELL_ROW_44_331 VGND VPWR sky130_fd_sc_hd__tapvpwrvgnd_1
XFILLER_37_141 VGND VGND VPWR VPWR sky130_fd_sc_hd__decap_4
Xhold76 mem\[12\]\[0\] VGND VGND VPWR VPWR net152 sky130_fd_sc_hd__dlygate4sd3_1
Xhold10 mem\[5\]\[0\] VGND VGND VPWR VPWR net86 sky130_fd_sc_hd__dlygate4sd3_1
Xhold54 mem\[10\]\[4\] VGND VGND VPWR VPWR net130 sky130_fd_sc_hd__dlygate4sd3_1
X_592_ net59 net186 _301_ VGND VGND VPWR VPWR _099_ sky130_fd_sc_hd__mux2_1
Xhold32 mem\[10\]\[3\] VGND VGND VPWR VPWR net108 sky130_fd_sc_hd__dlygate4sd3_1
X_661_ clknet_4_2_0_wr_clk _029_ VGND VGND VPWR VPWR mem\[12\]\[5\] sky130_fd_sc_hd__dfxtp_1
Xhold65 mem\[12\]\[4\] VGND VGND VPWR VPWR net141 sky130_fd_sc_hd__dlygate4sd3_1
Xhold21 mem\[10\]\[7\] VGND VGND VPWR VPWR net97 sky130_fd_sc_hd__dlygate4sd3_1
Xhold87 mem\[14\]\[7\] VGND VGND VPWR VPWR net163 sky130_fd_sc_hd__dlygate4sd3_1
Xhold98 mem\[1\]\[2\] VGND VGND VPWR VPWR net174 sky130_fd_sc_hd__dlygate4sd3_1
X_730_ clknet_4_6_0_wr_clk _098_ VGND VGND VPWR VPWR mem\[3\]\[2\] sky130_fd_sc_hd__dfxtp_1
XFILLER_28_141 VGND VGND VPWR VPWR sky130_fd_sc_hd__decap_4
Xhold43 mem\[0\]\[0\] VGND VGND VPWR VPWR net119 sky130_fd_sc_hd__dlygate4sd3_1
XFILLER_43_199 VPWR VGND VPWR VGND sky130_ef_sc_hd__decap_12
XFILLER_43_122 VGND VGND VPWR VPWR sky130_fd_sc_hd__decap_4
XTAP_TAPCELL_ROW_41_312 VGND VPWR sky130_fd_sc_hd__tapvpwrvgnd_1
XFILLER_3_273 VGND VGND VPWR VPWR sky130_fd_sc_hd__decap_6
XFILLER_34_188 VGND VGND VPWR VPWR sky130_fd_sc_hd__decap_8
XPHY_EDGE_ROW_11_Left_62 VGND VGND VPWR VPWR sky130_fd_sc_hd__decap_3
XFILLER_15_34 VGND VGND VPWR VPWR sky130_fd_sc_hd__decap_4
Xoutput33 net33 VGND VGND VPWR VPWR rd_data[6] sky130_fd_sc_hd__buf_2
XFILLER_0_221 VGND VGND VPWR VPWR sky130_fd_sc_hd__decap_3
XFILLER_0_265 VPWR VGND VPWR VGND sky130_ef_sc_hd__decap_12
X_575_ net140 net58 _299_ VGND VGND VPWR VPWR _084_ sky130_fd_sc_hd__mux2_1
XFILLER_16_111 VGND VGND VPWR VPWR sky130_fd_sc_hd__decap_6
X_644_ clknet_4_11_0_wr_clk _012_ VGND VGND VPWR VPWR mem\[14\]\[4\] sky130_fd_sc_hd__dfxtp_1
X_713_ clknet_4_8_0_wr_clk _081_ VGND VGND VPWR VPWR mem\[6\]\[1\] sky130_fd_sc_hd__dfxtp_1
XFILLER_31_169 VGND VGND VPWR VPWR sky130_fd_sc_hd__fill_2
XTAP_TAPCELL_ROW_17_194 VGND VPWR sky130_fd_sc_hd__tapvpwrvgnd_1
Xclkbuf_4_1_0_wr_clk clknet_0_wr_clk VGND VGND VPWR VPWR clknet_4_1_0_wr_clk sky130_fd_sc_hd__clkbuf_8
XFILLER_38_280 VGND VGND VPWR VPWR sky130_fd_sc_hd__fill_1
XFILLER_42_21 VGND VGND VPWR VPWR sky130_fd_sc_hd__decap_6
X_360_ wr_bin_sync\[4\] rd_bin\[4\] VGND VGND VPWR VPWR _190_ sky130_fd_sc_hd__xor2_1
XFILLER_36_206 VGND VGND VPWR VPWR sky130_fd_sc_hd__decap_4
XTAP_TAPCELL_ROW_8_151 VGND VPWR sky130_fd_sc_hd__tapvpwrvgnd_1
XFILLER_3_15 VPWR VGND VPWR VGND sky130_ef_sc_hd__decap_12
X_558_ net137 net53 _296_ VGND VGND VPWR VPWR _070_ sky130_fd_sc_hd__mux2_1
X_627_ net159 net59 _304_ VGND VGND VPWR VPWR _131_ sky130_fd_sc_hd__mux2_1
XFILLER_12_191 VGND VGND VPWR VPWR sky130_fd_sc_hd__decap_4
X_489_ net138 net57 _285_ VGND VGND VPWR VPWR _012_ sky130_fd_sc_hd__mux2_1
XFILLER_50_253 VGND VGND VPWR VPWR sky130_fd_sc_hd__decap_8
XFILLER_10_128 VPWR VGND VPWR VGND sky130_ef_sc_hd__decap_12
XFILLER_37_21 VGND VGND VPWR VPWR sky130_fd_sc_hd__decap_4
XTAP_TAPCELL_ROW_5_132 VGND VPWR sky130_fd_sc_hd__tapvpwrvgnd_1
X_412_ net40 _230_ VGND VGND VPWR VPWR _231_ sky130_fd_sc_hd__nor2_1
XFILLER_26_250 VGND VGND VPWR VPWR sky130_fd_sc_hd__fill_2
XFILLER_33_209 VPWR VGND VPWR VGND sky130_ef_sc_hd__decap_12
X_343_ _139_ _161_ _162_ _165_ _173_ VGND VGND VPWR VPWR _174_ sky130_fd_sc_hd__a32o_1
XFILLER_41_297 VGND VGND VPWR VPWR sky130_fd_sc_hd__decap_4
XFILLER_41_253 VPWR VGND VPWR VGND sky130_ef_sc_hd__decap_12
XFILLER_5_187 VPWR VGND VPWR VGND sky130_ef_sc_hd__decap_12
XFILLER_17_250 VGND VGND VPWR VPWR sky130_fd_sc_hd__fill_1
XFILLER_17_272 VGND VGND VPWR VPWR sky130_fd_sc_hd__decap_3
XFILLER_32_253 VPWR VGND VPWR VGND sky130_ef_sc_hd__decap_12
XFILLER_23_220 VGND VGND VPWR VPWR sky130_fd_sc_hd__fill_1
XFILLER_48_97 VGND VGND VPWR VPWR sky130_fd_sc_hd__decap_6
XFILLER_48_53 VPWR VGND VPWR VGND sky130_ef_sc_hd__decap_12
XFILLER_0_27 VGND VGND VPWR VPWR sky130_fd_sc_hd__fill_1
X_326_ _151_ _154_ _156_ VGND VGND VPWR VPWR _157_ sky130_fd_sc_hd__a21o_1
XFILLER_14_253 VPWR VGND VPWR VGND sky130_ef_sc_hd__decap_12
XFILLER_14_275 VGND VGND VPWR VPWR sky130_fd_sc_hd__fill_1
XFILLER_29_3 VGND VGND VPWR VPWR sky130_fd_sc_hd__decap_8
XFILLER_49_161 VGND VGND VPWR VPWR sky130_fd_sc_hd__decap_6
XFILLER_37_301 VGND VGND VPWR VPWR sky130_fd_sc_hd__fill_1
XTAP_TAPCELL_ROW_22_218 VGND VPWR sky130_fd_sc_hd__tapvpwrvgnd_1
XPHY_EDGE_ROW_41_Left_92 VGND VGND VPWR VPWR sky130_fd_sc_hd__decap_3
XFILLER_11_223 VGND VGND VPWR VPWR sky130_fd_sc_hd__fill_1
XFILLER_34_66 VGND VGND VPWR VPWR sky130_fd_sc_hd__decap_6
XFILLER_7_249 VPWR VGND VPWR VGND sky130_ef_sc_hd__decap_12
X_309_ net9 VGND VGND VPWR VPWR _140_ sky130_fd_sc_hd__inv_2
XFILLER_37_153 VGND VGND VPWR VPWR sky130_fd_sc_hd__decap_6
XFILLER_1_81 VPWR VGND VPWR VGND sky130_ef_sc_hd__decap_12
XTAP_TAPCELL_ROW_50_357 VGND VPWR sky130_fd_sc_hd__tapvpwrvgnd_1
Xhold22 mem\[5\]\[5\] VGND VGND VPWR VPWR net98 sky130_fd_sc_hd__dlygate4sd3_1
Xhold11 mem\[0\]\[1\] VGND VGND VPWR VPWR net87 sky130_fd_sc_hd__dlygate4sd3_1
XFILLER_29_11 VGND VGND VPWR VPWR sky130_fd_sc_hd__fill_1
Xhold33 mem\[9\]\[0\] VGND VGND VPWR VPWR net109 sky130_fd_sc_hd__dlygate4sd3_1
Xhold44 mem\[8\]\[0\] VGND VGND VPWR VPWR net120 sky130_fd_sc_hd__dlygate4sd3_1
XFILLER_43_101 VGND VGND VPWR VPWR sky130_fd_sc_hd__fill_2
Xhold88 mem\[2\]\[3\] VGND VGND VPWR VPWR net164 sky130_fd_sc_hd__dlygate4sd3_1
Xhold99 mem\[12\]\[5\] VGND VGND VPWR VPWR net175 sky130_fd_sc_hd__dlygate4sd3_1
Xhold77 mem\[14\]\[5\] VGND VGND VPWR VPWR net153 sky130_fd_sc_hd__dlygate4sd3_1
X_660_ clknet_4_11_0_wr_clk _028_ VGND VGND VPWR VPWR mem\[12\]\[4\] sky130_fd_sc_hd__dfxtp_1
Xhold66 mem\[7\]\[1\] VGND VGND VPWR VPWR net142 sky130_fd_sc_hd__dlygate4sd3_1
X_591_ net62 net191 _301_ VGND VGND VPWR VPWR _098_ sky130_fd_sc_hd__mux2_1
XFILLER_29_55 VGND VGND VPWR VPWR sky130_fd_sc_hd__fill_1
Xhold55 mem\[8\]\[1\] VGND VGND VPWR VPWR net131 sky130_fd_sc_hd__dlygate4sd3_1
XTAP_TAPCELL_ROW_41_313 VGND VPWR sky130_fd_sc_hd__tapvpwrvgnd_1
XFILLER_6_15 VPWR VGND VPWR VGND sky130_ef_sc_hd__decap_12
XFILLER_20_7 VGND VGND VPWR VPWR sky130_fd_sc_hd__decap_6
X_789_ clknet_4_11_0_wr_clk net77 net71 VGND VGND VPWR VPWR full_compare\[0\] sky130_fd_sc_hd__dfrtp_1
XFILLER_34_101 VGND VGND VPWR VPWR sky130_fd_sc_hd__fill_1
XFILLER_15_57 VGND VGND VPWR VPWR sky130_fd_sc_hd__decap_4
XFILLER_15_79 VPWR VGND VPWR VGND sky130_ef_sc_hd__decap_12
Xoutput23 net23 VGND VGND VPWR VPWR aempty sky130_fd_sc_hd__buf_2
Xoutput34 net34 VGND VGND VPWR VPWR rd_data[7] sky130_fd_sc_hd__buf_2
X_712_ clknet_4_6_0_wr_clk _080_ VGND VGND VPWR VPWR mem\[6\]\[0\] sky130_fd_sc_hd__dfxtp_1
XFILLER_0_277 VGND VGND VPWR VPWR sky130_fd_sc_hd__decap_3
X_574_ net144 net60 _299_ VGND VGND VPWR VPWR _083_ sky130_fd_sc_hd__mux2_1
X_643_ clknet_4_3_0_wr_clk _011_ VGND VGND VPWR VPWR mem\[14\]\[3\] sky130_fd_sc_hd__dfxtp_1
XFILLER_47_281 VPWR VGND VPWR VGND sky130_ef_sc_hd__decap_12
XFILLER_11_3 VGND VGND VPWR VPWR sky130_fd_sc_hd__decap_3
XTAP_TAPCELL_ROW_17_195 VGND VPWR sky130_fd_sc_hd__tapvpwrvgnd_1
XFILLER_26_45 VGND VGND VPWR VPWR sky130_fd_sc_hd__decap_8
XFILLER_42_88 VGND VGND VPWR VPWR sky130_fd_sc_hd__decap_4
XFILLER_9_108 VGND VGND VPWR VPWR sky130_fd_sc_hd__decap_4
XFILLER_3_27 VGND VGND VPWR VPWR sky130_fd_sc_hd__decap_8
XFILLER_29_281 VPWR VGND VPWR VGND sky130_ef_sc_hd__decap_12
XFILLER_44_251 VGND VGND VPWR VPWR sky130_fd_sc_hd__fill_1
X_557_ net146 net55 _296_ VGND VGND VPWR VPWR _069_ sky130_fd_sc_hd__mux2_1
X_488_ net139 net59 _285_ VGND VGND VPWR VPWR _011_ sky130_fd_sc_hd__mux2_1
X_626_ net179 net61 _304_ VGND VGND VPWR VPWR _130_ sky130_fd_sc_hd__mux2_1
XFILLER_12_170 VGND VGND VPWR VPWR sky130_fd_sc_hd__fill_2
XFILLER_27_229 VGND VGND VPWR VPWR sky130_fd_sc_hd__fill_1
XFILLER_50_265 VPWR VGND VPWR VGND sky130_ef_sc_hd__decap_12
XFILLER_35_295 VGND VGND VPWR VPWR sky130_fd_sc_hd__fill_2
XFILLER_12_25 VGND VGND VPWR VPWR sky130_fd_sc_hd__decap_3
Xhold130 mem\[11\]\[2\] VGND VGND VPWR VPWR net206 sky130_fd_sc_hd__dlygate4sd3_1
XFILLER_37_55 VGND VGND VPWR VPWR sky130_fd_sc_hd__fill_1
XTAP_TAPCELL_ROW_5_133 VGND VPWR sky130_fd_sc_hd__tapvpwrvgnd_1
X_342_ _140_ _159_ _164_ _167_ _172_ VGND VGND VPWR VPWR _173_ sky130_fd_sc_hd__a32o_1
XFILLER_41_265 VPWR VGND VPWR VGND sky130_ef_sc_hd__decap_12
XTAP_TAPCELL_ROW_36_290 VGND VPWR sky130_fd_sc_hd__tapvpwrvgnd_1
X_411_ _229_ _230_ VGND VGND VPWR VPWR rd_bin_next\[1\] sky130_fd_sc_hd__nor2_1
XFILLER_5_199 VPWR VGND VPWR VGND sky130_ef_sc_hd__decap_12
XFILLER_5_166 VGND VGND VPWR VPWR sky130_fd_sc_hd__fill_2
XTAP_TAPCELL_ROW_19_202 VGND VPWR sky130_fd_sc_hd__tapvpwrvgnd_1
X_609_ net129 net61 _303_ VGND VGND VPWR VPWR _114_ sky130_fd_sc_hd__mux2_1
XFILLER_32_265 VGND VGND VPWR VPWR sky130_fd_sc_hd__decap_8
XFILLER_23_243 VGND VGND VPWR VPWR sky130_fd_sc_hd__decap_8
XFILLER_2_103 VGND VGND VPWR VPWR sky130_fd_sc_hd__fill_1
XFILLER_48_65 VPWR VGND VPWR VGND sky130_ef_sc_hd__decap_12
X_325_ _149_ _155_ VGND VGND VPWR VPWR _156_ sky130_fd_sc_hd__nand2_1
XFILLER_9_15 VGND VGND VPWR VPWR sky130_fd_sc_hd__decap_6
XFILLER_14_265 VGND VGND VPWR VPWR sky130_fd_sc_hd__fill_1
XFILLER_14_298 VGND VGND VPWR VPWR sky130_fd_sc_hd__fill_1
XFILLER_1_191 VPWR VGND VPWR VGND sky130_ef_sc_hd__decap_12
XFILLER_20_213 VPWR VGND VPWR VGND sky130_ef_sc_hd__decap_12
XTAP_TAPCELL_ROW_22_219 VGND VPWR sky130_fd_sc_hd__tapvpwrvgnd_1
Xclkload0 clknet_4_0_0_wr_clk VGND VGND VPWR VPWR clkload0/X sky130_fd_sc_hd__clkbuf_4
XFILLER_46_132 VGND VGND VPWR VPWR sky130_fd_sc_hd__decap_8
X_308_ net10 VGND VGND VPWR VPWR _139_ sky130_fd_sc_hd__inv_2
XFILLER_41_3 VGND VGND VPWR VPWR sky130_fd_sc_hd__fill_2
XFILLER_6_250 VGND VGND VPWR VPWR sky130_fd_sc_hd__fill_2
XFILLER_1_93 VPWR VGND VPWR VGND sky130_ef_sc_hd__decap_12
XTAP_TAPCELL_ROW_50_358 VGND VPWR sky130_fd_sc_hd__tapvpwrvgnd_1
XFILLER_4_209 VPWR VGND VPWR VGND sky130_ef_sc_hd__decap_12
Xhold45 mem\[5\]\[6\] VGND VGND VPWR VPWR net121 sky130_fd_sc_hd__dlygate4sd3_1
Xhold23 mem\[0\]\[3\] VGND VGND VPWR VPWR net99 sky130_fd_sc_hd__dlygate4sd3_1
Xhold56 mem\[5\]\[3\] VGND VGND VPWR VPWR net132 sky130_fd_sc_hd__dlygate4sd3_1
Xhold12 mem\[13\]\[4\] VGND VGND VPWR VPWR net88 sky130_fd_sc_hd__dlygate4sd3_1
XFILLER_29_78 VGND VGND VPWR VPWR sky130_fd_sc_hd__decap_4
Xhold34 mem\[12\]\[2\] VGND VGND VPWR VPWR net110 sky130_fd_sc_hd__dlygate4sd3_1
XFILLER_45_88 VPWR VGND VPWR VGND sky130_ef_sc_hd__decap_12
XFILLER_45_55 VGND VGND VPWR VPWR sky130_fd_sc_hd__fill_1
Xhold78 mem\[10\]\[6\] VGND VGND VPWR VPWR net154 sky130_fd_sc_hd__dlygate4sd3_1
Xhold67 mem\[6\]\[6\] VGND VGND VPWR VPWR net143 sky130_fd_sc_hd__dlygate4sd3_1
X_590_ net64 net200 _301_ VGND VGND VPWR VPWR _097_ sky130_fd_sc_hd__mux2_1
Xhold89 mem\[5\]\[1\] VGND VGND VPWR VPWR net165 sky130_fd_sc_hd__dlygate4sd3_1
XTAP_TAPCELL_ROW_41_314 VGND VPWR sky130_fd_sc_hd__tapvpwrvgnd_1
XFILLER_6_27 VGND VGND VPWR VPWR sky130_fd_sc_hd__fill_1
X_788_ clknet_4_14_0_wr_clk rd_bin\[4\] net72 VGND VGND VPWR VPWR rd_gray_sync1\[4\]
+ sky130_fd_sc_hd__dfrtp_1
Xoutput24 net24 VGND VGND VPWR VPWR afull sky130_fd_sc_hd__buf_2
XFILLER_31_57 VGND VGND VPWR VPWR sky130_fd_sc_hd__fill_2
XFILLER_48_227 VGND VGND VPWR VPWR sky130_fd_sc_hd__decap_3
X_711_ clknet_4_1_0_wr_clk _079_ VGND VGND VPWR VPWR mem\[7\]\[7\] sky130_fd_sc_hd__dfxtp_1
X_642_ clknet_4_4_0_wr_clk _010_ VGND VGND VPWR VPWR mem\[14\]\[2\] sky130_fd_sc_hd__dfxtp_1
XPHY_EDGE_ROW_19_Right_19 VGND VGND VPWR VPWR sky130_fd_sc_hd__decap_3
X_573_ net128 net61 _299_ VGND VGND VPWR VPWR _082_ sky130_fd_sc_hd__mux2_1
XFILLER_8_301 VGND VGND VPWR VPWR sky130_fd_sc_hd__fill_1
XFILLER_39_216 VGND VGND VPWR VPWR sky130_fd_sc_hd__fill_2
XFILLER_21_90 VGND VGND VPWR VPWR sky130_fd_sc_hd__fill_2
XPHY_EDGE_ROW_28_Right_28 VGND VGND VPWR VPWR sky130_fd_sc_hd__decap_3
XFILLER_47_293 VGND VGND VPWR VPWR sky130_fd_sc_hd__decap_8
XPHY_EDGE_ROW_37_Right_37 VGND VGND VPWR VPWR sky130_fd_sc_hd__decap_3
XTAP_TAPCELL_ROW_17_196 VGND VPWR sky130_fd_sc_hd__tapvpwrvgnd_1
XPHY_EDGE_ROW_46_Right_46 VGND VGND VPWR VPWR sky130_fd_sc_hd__decap_3
XFILLER_26_79 VGND VGND VPWR VPWR sky130_fd_sc_hd__decap_4
X_625_ net162 net63 _304_ VGND VGND VPWR VPWR _129_ sky130_fd_sc_hd__mux2_1
XFILLER_29_293 VGND VGND VPWR VPWR sky130_fd_sc_hd__decap_6
X_556_ net148 net57 _296_ VGND VGND VPWR VPWR _068_ sky130_fd_sc_hd__mux2_1
XTAP_TAPCELL_ROW_14_177 VGND VPWR sky130_fd_sc_hd__tapvpwrvgnd_1
X_487_ net184 net61 _285_ VGND VGND VPWR VPWR _010_ sky130_fd_sc_hd__mux2_1
XFILLER_50_233 VGND VGND VPWR VPWR sky130_fd_sc_hd__fill_1
XFILLER_50_277 VGND VGND VPWR VPWR sky130_fd_sc_hd__decap_3
XFILLER_50_244 VGND VGND VPWR VPWR sky130_fd_sc_hd__decap_4
Xhold120 mem\[11\]\[6\] VGND VGND VPWR VPWR net196 sky130_fd_sc_hd__dlygate4sd3_1
Xhold131 mem\[7\]\[6\] VGND VGND VPWR VPWR net207 sky130_fd_sc_hd__dlygate4sd3_1
XTAP_TAPCELL_ROW_5_134 VGND VPWR sky130_fd_sc_hd__tapvpwrvgnd_1
XTAP_TAPCELL_ROW_28_247 VGND VPWR sky130_fd_sc_hd__tapvpwrvgnd_1
X_341_ _141_ _157_ _166_ _169_ _171_ VGND VGND VPWR VPWR _172_ sky130_fd_sc_hd__a32o_1
XFILLER_41_277 VGND VGND VPWR VPWR sky130_fd_sc_hd__decap_3
XFILLER_41_222 VGND VGND VPWR VPWR sky130_fd_sc_hd__fill_2
XTAP_TAPCELL_ROW_36_291 VGND VPWR sky130_fd_sc_hd__tapvpwrvgnd_1
X_410_ net49 net45 net36 VGND VGND VPWR VPWR _230_ sky130_fd_sc_hd__and3_1
XTAP_TAPCELL_ROW_19_203 VGND VPWR sky130_fd_sc_hd__tapvpwrvgnd_1
X_608_ net111 net63 _303_ VGND VGND VPWR VPWR _113_ sky130_fd_sc_hd__mux2_1
X_539_ net147 net55 _294_ VGND VGND VPWR VPWR _053_ sky130_fd_sc_hd__mux2_1
XFILLER_23_25 VGND VGND VPWR VPWR sky130_fd_sc_hd__fill_1
XTAP_TAPCELL_ROW_33_272 VGND VPWR sky130_fd_sc_hd__tapvpwrvgnd_1
XFILLER_48_77 VGND VGND VPWR VPWR sky130_fd_sc_hd__decap_6
XFILLER_0_29 VPWR VGND VPWR VGND sky130_ef_sc_hd__decap_12
XFILLER_14_222 VGND VGND VPWR VPWR sky130_fd_sc_hd__decap_4
X_324_ wr_bin\[2\] _148_ VGND VGND VPWR VPWR _155_ sky130_fd_sc_hd__or2_1
Xfanout70 net71 VGND VGND VPWR VPWR net70 sky130_fd_sc_hd__clkbuf_4
XTAP_TAPCELL_ROW_47_342 VGND VPWR sky130_fd_sc_hd__tapvpwrvgnd_1
XFILLER_9_281 VPWR VGND VPWR VGND sky130_ef_sc_hd__decap_12
XFILLER_20_225 VGND VGND VPWR VPWR sky130_fd_sc_hd__decap_6
XFILLER_11_225 VPWR VGND VPWR VGND sky130_ef_sc_hd__decap_12
Xclkload1 clknet_4_1_0_wr_clk VGND VGND VPWR VPWR clkload1/X sky130_fd_sc_hd__clkbuf_4
XFILLER_1_3 VPWR VGND VPWR VGND sky130_ef_sc_hd__decap_12
XPHY_EDGE_ROW_28_Left_79 VGND VGND VPWR VPWR sky130_fd_sc_hd__decap_3
X_307_ wr_bin\[0\] VGND VGND VPWR VPWR _138_ sky130_fd_sc_hd__inv_2
XFILLER_34_3 VPWR VGND VPWR VGND sky130_ef_sc_hd__decap_12
XTAP_TAPCELL_ROW_50_359 VGND VPWR sky130_fd_sc_hd__tapvpwrvgnd_1
XFILLER_20_48 VGND VGND VPWR VPWR sky130_fd_sc_hd__fill_1
Xhold24 mem\[12\]\[6\] VGND VGND VPWR VPWR net100 sky130_fd_sc_hd__dlygate4sd3_1
Xhold46 mem\[0\]\[5\] VGND VGND VPWR VPWR net122 sky130_fd_sc_hd__dlygate4sd3_1
Xhold68 mem\[6\]\[3\] VGND VGND VPWR VPWR net144 sky130_fd_sc_hd__dlygate4sd3_1
Xhold57 mem\[8\]\[7\] VGND VGND VPWR VPWR net133 sky130_fd_sc_hd__dlygate4sd3_1
Xhold35 mem\[4\]\[1\] VGND VGND VPWR VPWR net111 sky130_fd_sc_hd__dlygate4sd3_1
Xhold79 mem\[6\]\[7\] VGND VGND VPWR VPWR net155 sky130_fd_sc_hd__dlygate4sd3_1
Xhold13 mem\[0\]\[2\] VGND VGND VPWR VPWR net89 sky130_fd_sc_hd__dlygate4sd3_1
XFILLER_29_57 VPWR VGND VPWR VGND sky130_ef_sc_hd__decap_12
XFILLER_43_169 VGND VGND VPWR VPWR sky130_fd_sc_hd__decap_4
XTAP_TAPCELL_ROW_41_315 VGND VPWR sky130_fd_sc_hd__tapvpwrvgnd_1
XFILLER_3_221 VGND VGND VPWR VPWR sky130_fd_sc_hd__decap_3
X_787_ clknet_4_15_0_wr_clk rd_gray\[3\] net73 VGND VGND VPWR VPWR rd_gray_sync1\[3\]
+ sky130_fd_sc_hd__dfrtp_1
XFILLER_15_15 VGND VGND VPWR VPWR sky130_fd_sc_hd__decap_3
XFILLER_25_169 VPWR VGND VPWR VGND sky130_ef_sc_hd__decap_12
Xoutput25 net25 VGND VGND VPWR VPWR empty sky130_fd_sc_hd__buf_2
X_710_ clknet_4_5_0_wr_clk _078_ VGND VGND VPWR VPWR mem\[7\]\[6\] sky130_fd_sc_hd__dfxtp_1
XFILLER_16_103 VGND VGND VPWR VPWR sky130_fd_sc_hd__fill_1
X_572_ net101 net63 _299_ VGND VGND VPWR VPWR _081_ sky130_fd_sc_hd__mux2_1
X_641_ clknet_4_12_0_wr_clk _009_ VGND VGND VPWR VPWR mem\[14\]\[1\] sky130_fd_sc_hd__dfxtp_1
XFILLER_16_125 VPWR VGND VPWR VGND sky130_ef_sc_hd__decap_12
XFILLER_30_150 VGND VGND VPWR VPWR sky130_fd_sc_hd__decap_4
XPHY_EDGE_ROW_15_Left_66 VGND VGND VPWR VPWR sky130_fd_sc_hd__decap_3
X_624_ net109 net66 _304_ VGND VGND VPWR VPWR _128_ sky130_fd_sc_hd__mux2_1
X_555_ net91 net59 _296_ VGND VGND VPWR VPWR _067_ sky130_fd_sc_hd__mux2_1
XFILLER_29_261 VPWR VGND VPWR VGND sky130_ef_sc_hd__decap_12
XFILLER_8_132 VGND VGND VPWR VPWR sky130_fd_sc_hd__decap_8
XTAP_TAPCELL_ROW_14_178 VGND VPWR sky130_fd_sc_hd__tapvpwrvgnd_1
X_486_ net83 net63 _285_ VGND VGND VPWR VPWR _009_ sky130_fd_sc_hd__mux2_1
XFILLER_8_165 VGND VGND VPWR VPWR sky130_fd_sc_hd__decap_3
Xhold110 mem\[3\]\[3\] VGND VGND VPWR VPWR net186 sky130_fd_sc_hd__dlygate4sd3_1
XTAP_TAPCELL_ROW_5_135 VGND VPWR sky130_fd_sc_hd__tapvpwrvgnd_1
Xhold132 mem\[11\]\[7\] VGND VGND VPWR VPWR net208 sky130_fd_sc_hd__dlygate4sd3_1
Xhold121 mem\[15\]\[2\] VGND VGND VPWR VPWR net197 sky130_fd_sc_hd__dlygate4sd3_1
XFILLER_37_57 VGND VGND VPWR VPWR sky130_fd_sc_hd__fill_1
XFILLER_26_242 VGND VGND VPWR VPWR sky130_fd_sc_hd__decap_8
XTAP_TAPCELL_ROW_28_248 VGND VPWR sky130_fd_sc_hd__tapvpwrvgnd_1
X_340_ _138_ _152_ _170_ _143_ VGND VGND VPWR VPWR _171_ sky130_fd_sc_hd__a211o_1
XFILLER_5_146 VPWR VGND VPWR VGND sky130_ef_sc_hd__decap_12
XFILLER_5_113 VGND VGND VPWR VPWR sky130_fd_sc_hd__decap_4
XFILLER_5_102 VGND VGND VPWR VPWR sky130_fd_sc_hd__fill_2
XFILLER_49_301 VGND VGND VPWR VPWR sky130_fd_sc_hd__fill_1
XTAP_TAPCELL_ROW_19_204 VGND VPWR sky130_fd_sc_hd__tapvpwrvgnd_1
X_607_ net203 net65 _303_ VGND VGND VPWR VPWR _112_ sky130_fd_sc_hd__mux2_1
X_538_ net130 net57 _294_ VGND VGND VPWR VPWR _052_ sky130_fd_sc_hd__mux2_1
XFILLER_17_264 VGND VGND VPWR VPWR sky130_fd_sc_hd__decap_8
X_469_ _270_ _272_ _269_ _271_ net39 net40 VGND VGND VPWR VPWR _273_ sky130_fd_sc_hd__mux4_1
XFILLER_4_83 VGND VGND VPWR VPWR sky130_fd_sc_hd__fill_1
XTAP_TAPCELL_ROW_33_273 VGND VPWR sky130_fd_sc_hd__tapvpwrvgnd_1
XFILLER_2_138 VGND VGND VPWR VPWR sky130_fd_sc_hd__fill_2
XFILLER_2_149 VPWR VGND VPWR VGND sky130_ef_sc_hd__decap_12
X_323_ _138_ _152_ _153_ VGND VGND VPWR VPWR _154_ sky130_fd_sc_hd__a21o_1
Xfanout60 net17 VGND VGND VPWR VPWR net60 sky130_fd_sc_hd__buf_1
Xfanout71 net76 VGND VGND VPWR VPWR net71 sky130_fd_sc_hd__buf_2
XTAP_TAPCELL_ROW_47_343 VGND VPWR sky130_fd_sc_hd__tapvpwrvgnd_1
XFILLER_9_293 VGND VGND VPWR VPWR sky130_fd_sc_hd__decap_8
XFILLER_50_57 VPWR VGND VPWR VGND sky130_ef_sc_hd__decap_12
Xclkload2 clknet_4_2_0_wr_clk VGND VGND VPWR VPWR clkload2/X sky130_fd_sc_hd__clkbuf_8
XFILLER_11_237 VPWR VGND VPWR VGND sky130_ef_sc_hd__decap_12
XPHY_EDGE_ROW_3_Left_54 VGND VGND VPWR VPWR sky130_fd_sc_hd__decap_3
X_306_ wr_bin\[1\] VGND VGND VPWR VPWR _137_ sky130_fd_sc_hd__inv_2
XFILLER_6_230 VPWR VGND VPWR VGND sky130_ef_sc_hd__decap_12
XFILLER_27_3 VGND VGND VPWR VPWR sky130_fd_sc_hd__fill_2
XPHY_EDGE_ROW_45_Left_96 VGND VGND VPWR VPWR sky130_fd_sc_hd__decap_3
Xclkbuf_4_4_0_wr_clk clknet_0_wr_clk VGND VGND VPWR VPWR clknet_4_4_0_wr_clk sky130_fd_sc_hd__clkbuf_8
Xhold69 mem\[9\]\[5\] VGND VGND VPWR VPWR net145 sky130_fd_sc_hd__dlygate4sd3_1
Xhold47 mem\[6\]\[5\] VGND VGND VPWR VPWR net123 sky130_fd_sc_hd__dlygate4sd3_1
Xhold58 mem\[0\]\[4\] VGND VGND VPWR VPWR net134 sky130_fd_sc_hd__dlygate4sd3_1
Xhold14 mem\[0\]\[7\] VGND VGND VPWR VPWR net90 sky130_fd_sc_hd__dlygate4sd3_1
Xhold25 mem\[6\]\[1\] VGND VGND VPWR VPWR net101 sky130_fd_sc_hd__dlygate4sd3_1
Xhold36 mem\[5\]\[7\] VGND VGND VPWR VPWR net112 sky130_fd_sc_hd__dlygate4sd3_1
XFILLER_28_123 VGND VGND VPWR VPWR sky130_fd_sc_hd__fill_1
XFILLER_28_145 VGND VGND VPWR VPWR sky130_fd_sc_hd__fill_1
XFILLER_45_57 VGND VGND VPWR VPWR sky130_fd_sc_hd__decap_6
XTAP_TAPCELL_ROW_41_316 VGND VPWR sky130_fd_sc_hd__tapvpwrvgnd_1
XFILLER_10_93 VGND VGND VPWR VPWR sky130_fd_sc_hd__decap_3
XFILLER_19_101 VGND VGND VPWR VPWR sky130_fd_sc_hd__fill_2
XFILLER_34_126 VGND VGND VPWR VPWR sky130_fd_sc_hd__decap_4
X_786_ clknet_4_14_0_wr_clk rd_gray\[2\] net72 VGND VGND VPWR VPWR rd_gray_sync1\[2\]
+ sky130_fd_sc_hd__dfrtp_1
XFILLER_15_38 VGND VGND VPWR VPWR sky130_fd_sc_hd__fill_1
XFILLER_25_137 VGND VGND VPWR VPWR sky130_fd_sc_hd__decap_4
XFILLER_33_181 VGND VGND VPWR VPWR sky130_fd_sc_hd__decap_6
Xoutput26 net26 VGND VGND VPWR VPWR full sky130_fd_sc_hd__buf_2
XFILLER_0_225 VPWR VGND VPWR VGND sky130_ef_sc_hd__decap_12
XPHY_EDGE_ROW_1_Right_1 VGND VGND VPWR VPWR sky130_fd_sc_hd__decap_3
X_640_ clknet_4_7_0_wr_clk _008_ VGND VGND VPWR VPWR mem\[14\]\[0\] sky130_fd_sc_hd__dfxtp_1
X_571_ net118 net65 _299_ VGND VGND VPWR VPWR _080_ sky130_fd_sc_hd__mux2_1
XFILLER_16_137 VGND VGND VPWR VPWR sky130_fd_sc_hd__decap_3
XFILLER_22_129 VGND VGND VPWR VPWR sky130_fd_sc_hd__fill_2
X_769_ clknet_4_1_0_wr_clk _119_ VGND VGND VPWR VPWR mem\[4\]\[7\] sky130_fd_sc_hd__dfxtp_1
XFILLER_7_61 VGND VGND VPWR VPWR sky130_fd_sc_hd__fill_1
XFILLER_38_262 VPWR VGND VPWR VGND sky130_ef_sc_hd__decap_12
XFILLER_38_251 VGND VGND VPWR VPWR sky130_fd_sc_hd__fill_1
XFILLER_44_243 VGND VGND VPWR VPWR sky130_fd_sc_hd__decap_8
XFILLER_44_221 VPWR VGND VPWR VGND sky130_ef_sc_hd__decap_12
X_485_ net136 net65 _285_ VGND VGND VPWR VPWR _008_ sky130_fd_sc_hd__mux2_1
X_623_ _286_ _290_ VGND VGND VPWR VPWR _304_ sky130_fd_sc_hd__nor2_4
X_554_ net104 net61 _296_ VGND VGND VPWR VPWR _066_ sky130_fd_sc_hd__mux2_1
XFILLER_29_273 VGND VGND VPWR VPWR sky130_fd_sc_hd__decap_6
XPHY_EDGE_ROW_32_Left_83 VGND VGND VPWR VPWR sky130_fd_sc_hd__decap_3
XFILLER_8_122 VGND VGND VPWR VPWR sky130_fd_sc_hd__fill_2
XFILLER_12_195 VGND VGND VPWR VPWR sky130_fd_sc_hd__fill_1
XTAP_TAPCELL_ROW_14_179 VGND VPWR sky130_fd_sc_hd__tapvpwrvgnd_1
XFILLER_16_81 VGND VGND VPWR VPWR sky130_fd_sc_hd__decap_3
XFILLER_32_91 VGND VGND VPWR VPWR sky130_fd_sc_hd__fill_1
Xhold122 mem\[15\]\[0\] VGND VGND VPWR VPWR net198 sky130_fd_sc_hd__dlygate4sd3_1
Xhold133 mem\[5\]\[4\] VGND VGND VPWR VPWR net209 sky130_fd_sc_hd__dlygate4sd3_1
Xhold111 mem\[3\]\[7\] VGND VGND VPWR VPWR net187 sky130_fd_sc_hd__dlygate4sd3_1
Xhold100 mem\[15\]\[1\] VGND VGND VPWR VPWR net176 sky130_fd_sc_hd__dlygate4sd3_1
XTAP_TAPCELL_ROW_5_136 VGND VPWR sky130_fd_sc_hd__tapvpwrvgnd_1
XFILLER_41_213 VGND VGND VPWR VPWR sky130_fd_sc_hd__fill_2
XFILLER_37_25 VGND VGND VPWR VPWR sky130_fd_sc_hd__fill_1
XFILLER_26_232 VGND VGND VPWR VPWR sky130_fd_sc_hd__decap_3
XTAP_TAPCELL_ROW_28_249 VGND VPWR sky130_fd_sc_hd__tapvpwrvgnd_1
XFILLER_5_169 VGND VGND VPWR VPWR sky130_fd_sc_hd__fill_1
XFILLER_5_158 VGND VGND VPWR VPWR sky130_fd_sc_hd__decap_8
XFILLER_5_125 VPWR VGND VPWR VGND sky130_ef_sc_hd__decap_12
XTAP_TAPCELL_ROW_19_205 VGND VPWR sky130_fd_sc_hd__tapvpwrvgnd_1
X_606_ _288_ _297_ VGND VGND VPWR VPWR _303_ sky130_fd_sc_hd__nor2_4
X_537_ net108 net59 _294_ VGND VGND VPWR VPWR _051_ sky130_fd_sc_hd__mux2_1
X_468_ mem\[8\]\[5\] mem\[9\]\[5\] mem\[10\]\[5\] mem\[11\]\[5\] net46 net42 VGND
+ VGND VPWR VPWR _272_ sky130_fd_sc_hd__mux4_1
X_399_ net37 net38 VGND VGND VPWR VPWR _221_ sky130_fd_sc_hd__nand2_2
XTAP_TAPCELL_ROW_10_160 VGND VPWR sky130_fd_sc_hd__tapvpwrvgnd_1
XTAP_TAPCELL_ROW_2_117 VGND VPWR sky130_fd_sc_hd__tapvpwrvgnd_1
XTAP_TAPCELL_ROW_33_274 VGND VPWR sky130_fd_sc_hd__tapvpwrvgnd_1
X_322_ _137_ _150_ VGND VGND VPWR VPWR _153_ sky130_fd_sc_hd__xnor2_1
XFILLER_9_29 VPWR VGND VPWR VGND sky130_ef_sc_hd__decap_12
XTAP_TAPCELL_ROW_24_230 VGND VPWR sky130_fd_sc_hd__tapvpwrvgnd_1
Xfanout50 rd_bin\[0\] VGND VGND VPWR VPWR net50 sky130_fd_sc_hd__clkbuf_2
Xfanout61 net16 VGND VGND VPWR VPWR net61 sky130_fd_sc_hd__clkbuf_2
Xfanout72 net73 VGND VGND VPWR VPWR net72 sky130_fd_sc_hd__clkbuf_4
XTAP_TAPCELL_ROW_47_344 VGND VPWR sky130_fd_sc_hd__tapvpwrvgnd_1
XFILLER_9_261 VPWR VGND VPWR VGND sky130_ef_sc_hd__decap_12
XTAP_TAPCELL_ROW_38_300 VGND VPWR sky130_fd_sc_hd__tapvpwrvgnd_1
XFILLER_18_27 VGND VGND VPWR VPWR sky130_fd_sc_hd__fill_1
XFILLER_11_205 VPWR VGND VPWR VGND sky130_ef_sc_hd__decap_12
XFILLER_34_15 VGND VGND VPWR VPWR sky130_fd_sc_hd__decap_4
XFILLER_34_37 VGND VGND VPWR VPWR sky130_fd_sc_hd__decap_6
XFILLER_50_69 VPWR VGND VPWR VGND sky130_ef_sc_hd__decap_12
XFILLER_11_249 VGND VGND VPWR VPWR sky130_fd_sc_hd__decap_8
Xclkload3 clknet_4_3_0_wr_clk VGND VGND VPWR VPWR clkload3/Y sky130_fd_sc_hd__clkinv_4
X_305_ full_compare\[1\] VGND VGND VPWR VPWR _136_ sky130_fd_sc_hd__inv_2
XFILLER_6_253 VPWR VGND VPWR VGND sky130_ef_sc_hd__decap_12
XFILLER_6_242 VGND VGND VPWR VPWR sky130_fd_sc_hd__decap_8
XFILLER_10_282 VPWR VGND VPWR VGND sky130_ef_sc_hd__decap_12
XFILLER_45_47 VGND VGND VPWR VPWR sky130_fd_sc_hd__decap_8
Xhold37 mem\[2\]\[6\] VGND VGND VPWR VPWR net113 sky130_fd_sc_hd__dlygate4sd3_1
Xhold15 mem\[8\]\[3\] VGND VGND VPWR VPWR net91 sky130_fd_sc_hd__dlygate4sd3_1
Xhold48 mem\[12\]\[7\] VGND VGND VPWR VPWR net124 sky130_fd_sc_hd__dlygate4sd3_1
Xhold26 mem\[13\]\[7\] VGND VGND VPWR VPWR net102 sky130_fd_sc_hd__dlygate4sd3_1
Xhold59 mem\[10\]\[1\] VGND VGND VPWR VPWR net135 sky130_fd_sc_hd__dlygate4sd3_1
XFILLER_10_83 VGND VGND VPWR VPWR sky130_fd_sc_hd__fill_1
XFILLER_19_113 VGND VGND VPWR VPWR sky130_fd_sc_hd__fill_2
X_785_ clknet_4_12_0_wr_clk rd_gray\[1\] net70 VGND VGND VPWR VPWR rd_gray_sync1\[1\]
+ sky130_fd_sc_hd__dfrtp_1
XFILLER_35_91 VGND VGND VPWR VPWR sky130_fd_sc_hd__fill_1
Xoutput27 net27 VGND VGND VPWR VPWR rd_data[0] sky130_fd_sc_hd__buf_2
XFILLER_48_219 VGND VGND VPWR VPWR sky130_fd_sc_hd__decap_8
XFILLER_0_237 VPWR VGND VPWR VGND sky130_ef_sc_hd__decap_12
X_570_ _284_ _297_ VGND VGND VPWR VPWR _299_ sky130_fd_sc_hd__nor2_4
XFILLER_21_82 VGND VGND VPWR VPWR sky130_fd_sc_hd__decap_8
XFILLER_47_252 VPWR VGND VPWR VGND sky130_ef_sc_hd__decap_12
XFILLER_39_208 VGND VGND VPWR VPWR sky130_fd_sc_hd__decap_8
X_768_ clknet_4_5_0_wr_clk _118_ VGND VGND VPWR VPWR mem\[4\]\[6\] sky130_fd_sc_hd__dfxtp_1
X_699_ clknet_4_2_0_wr_clk _067_ VGND VGND VPWR VPWR mem\[8\]\[3\] sky130_fd_sc_hd__dfxtp_1
XFILLER_7_51 VGND VGND VPWR VPWR sky130_fd_sc_hd__decap_4
XFILLER_30_163 VGND VGND VPWR VPWR sky130_fd_sc_hd__fill_2
XPHY_EDGE_ROW_15_Right_15 VGND VGND VPWR VPWR sky130_fd_sc_hd__decap_3
XFILLER_38_274 VGND VGND VPWR VPWR sky130_fd_sc_hd__decap_6
XPHY_EDGE_ROW_24_Right_24 VGND VGND VPWR VPWR sky130_fd_sc_hd__decap_3
XPHY_EDGE_ROW_33_Right_33 VGND VGND VPWR VPWR sky130_fd_sc_hd__decap_3
X_622_ net52 net204 net35 VGND VGND VPWR VPWR _127_ sky130_fd_sc_hd__mux2_1
XFILLER_44_233 VGND VGND VPWR VPWR sky130_fd_sc_hd__decap_6
X_484_ _221_ _284_ VGND VGND VPWR VPWR _285_ sky130_fd_sc_hd__nor2_4
XPHY_EDGE_ROW_42_Right_42 VGND VGND VPWR VPWR sky130_fd_sc_hd__decap_3
X_553_ net131 net63 _296_ VGND VGND VPWR VPWR _065_ sky130_fd_sc_hd__mux2_1
XFILLER_12_141 VGND VGND VPWR VPWR sky130_fd_sc_hd__decap_4
XFILLER_50_225 VGND VGND VPWR VPWR sky130_fd_sc_hd__decap_8
Xhold123 mem\[11\]\[4\] VGND VGND VPWR VPWR net199 sky130_fd_sc_hd__dlygate4sd3_1
Xhold101 mem\[15\]\[4\] VGND VGND VPWR VPWR net177 sky130_fd_sc_hd__dlygate4sd3_1
Xhold112 mem\[10\]\[2\] VGND VGND VPWR VPWR net188 sky130_fd_sc_hd__dlygate4sd3_1
X_605_ net112 net51 _302_ VGND VGND VPWR VPWR _111_ sky130_fd_sc_hd__mux2_1
XTAP_TAPCELL_ROW_19_206 VGND VPWR sky130_fd_sc_hd__tapvpwrvgnd_1
X_398_ full_compare\[0\] wr_gray_next\[0\] VGND VGND VPWR VPWR _220_ sky130_fd_sc_hd__xnor2_1
X_467_ mem\[12\]\[5\] mem\[13\]\[5\] mem\[14\]\[5\] mem\[15\]\[5\] net46 net42 VGND
+ VGND VPWR VPWR _271_ sky130_fd_sc_hd__mux4_1
X_536_ net188 net61 _294_ VGND VGND VPWR VPWR _050_ sky130_fd_sc_hd__mux2_1
XTAP_TAPCELL_ROW_10_161 VGND VPWR sky130_fd_sc_hd__tapvpwrvgnd_1
XFILLER_4_85 VPWR VGND VPWR VGND sky130_ef_sc_hd__decap_12
XTAP_TAPCELL_ROW_2_118 VGND VPWR sky130_fd_sc_hd__tapvpwrvgnd_1
XTAP_TAPCELL_ROW_33_275 VGND VPWR sky130_fd_sc_hd__tapvpwrvgnd_1
X_321_ full_compare\[0\] _150_ VGND VGND VPWR VPWR _152_ sky130_fd_sc_hd__xor2_1
XFILLER_14_247 VGND VGND VPWR VPWR sky130_fd_sc_hd__decap_4
Xfanout51 net21 VGND VGND VPWR VPWR net51 sky130_fd_sc_hd__clkbuf_2
XTAP_TAPCELL_ROW_24_231 VGND VPWR sky130_fd_sc_hd__tapvpwrvgnd_1
Xfanout40 rd_bin\[2\] VGND VGND VPWR VPWR net40 sky130_fd_sc_hd__buf_4
Xfanout62 net16 VGND VGND VPWR VPWR net62 sky130_fd_sc_hd__buf_1
Xfanout73 net74 VGND VGND VPWR VPWR net73 sky130_fd_sc_hd__clkbuf_4
XFILLER_49_111 VGND VGND VPWR VPWR sky130_fd_sc_hd__fill_1
XFILLER_1_140 VPWR VGND VPWR VGND sky130_ef_sc_hd__decap_12
XTAP_TAPCELL_ROW_47_345 VGND VPWR sky130_fd_sc_hd__tapvpwrvgnd_1
XFILLER_38_80 VGND VGND VPWR VPWR sky130_fd_sc_hd__decap_4
X_519_ net57 net199 _291_ VGND VGND VPWR VPWR _036_ sky130_fd_sc_hd__mux2_1
XFILLER_9_273 VGND VGND VPWR VPWR sky130_fd_sc_hd__decap_6
Xclkload10 clknet_4_11_0_wr_clk VGND VGND VPWR VPWR clkload10/Y sky130_fd_sc_hd__inv_6
XFILLER_20_239 VPWR VGND VPWR VGND sky130_ef_sc_hd__decap_12
XTAP_TAPCELL_ROW_38_301 VGND VPWR sky130_fd_sc_hd__tapvpwrvgnd_1
XFILLER_11_217 VGND VGND VPWR VPWR sky130_fd_sc_hd__decap_6
XFILLER_50_15 VPWR VGND VPWR VGND sky130_ef_sc_hd__decap_12
XTAP_TAPCELL_ROW_21_212 VGND VPWR sky130_fd_sc_hd__tapvpwrvgnd_1
Xclkload4 clknet_4_4_0_wr_clk VGND VGND VPWR VPWR clkload4/X sky130_fd_sc_hd__clkbuf_8
XFILLER_46_103 VGND VGND VPWR VPWR sky130_fd_sc_hd__fill_1
XFILLER_6_265 VPWR VGND VPWR VGND sky130_ef_sc_hd__decap_12
XFILLER_10_294 VGND VGND VPWR VPWR sky130_fd_sc_hd__decap_4
XFILLER_37_169 VGND VGND VPWR VPWR sky130_fd_sc_hd__fill_1
XFILLER_20_29 VGND VGND VPWR VPWR sky130_fd_sc_hd__decap_4
Xhold38 mem\[4\]\[7\] VGND VGND VPWR VPWR net114 sky130_fd_sc_hd__dlygate4sd3_1
Xhold16 mem\[1\]\[1\] VGND VGND VPWR VPWR net92 sky130_fd_sc_hd__dlygate4sd3_1
XFILLER_29_49 VGND VGND VPWR VPWR sky130_fd_sc_hd__decap_6
Xhold27 mem\[13\]\[2\] VGND VGND VPWR VPWR net103 sky130_fd_sc_hd__dlygate4sd3_1
XFILLER_36_180 VGND VGND VPWR VPWR sky130_fd_sc_hd__decap_4
Xhold49 mem\[1\]\[6\] VGND VGND VPWR VPWR net125 sky130_fd_sc_hd__dlygate4sd3_1
XFILLER_3_279 VGND VGND VPWR VPWR sky130_fd_sc_hd__fill_1
X_784_ clknet_4_11_0_wr_clk rd_gray\[0\] net71 VGND VGND VPWR VPWR rd_gray_sync1\[0\]
+ sky130_fd_sc_hd__dfrtp_1
XFILLER_19_93 VGND VGND VPWR VPWR sky130_fd_sc_hd__decap_8
XFILLER_19_169 VPWR VGND VPWR VGND sky130_ef_sc_hd__decap_12
XFILLER_32_3 VGND VGND VPWR VPWR sky130_fd_sc_hd__decap_6
Xoutput28 net28 VGND VGND VPWR VPWR rd_data[1] sky130_fd_sc_hd__buf_2
XFILLER_0_249 VGND VGND VPWR VPWR sky130_fd_sc_hd__decap_3
XFILLER_47_264 VPWR VGND VPWR VGND sky130_ef_sc_hd__decap_12
X_767_ clknet_4_0_0_wr_clk _117_ VGND VGND VPWR VPWR mem\[4\]\[5\] sky130_fd_sc_hd__dfxtp_1
XFILLER_22_109 VPWR VGND VPWR VGND sky130_ef_sc_hd__decap_12
X_698_ clknet_4_4_0_wr_clk _066_ VGND VGND VPWR VPWR mem\[8\]\[2\] sky130_fd_sc_hd__dfxtp_1
XFILLER_38_253 VGND VGND VPWR VPWR sky130_fd_sc_hd__fill_2
XFILLER_38_231 VGND VGND VPWR VPWR sky130_fd_sc_hd__decap_8
XFILLER_42_27 VGND VGND VPWR VPWR sky130_fd_sc_hd__fill_1
X_621_ net54 net169 _222_ VGND VGND VPWR VPWR _126_ sky130_fd_sc_hd__mux2_1
X_483_ _137_ wr_bin\[0\] _208_ VGND VGND VPWR VPWR _284_ sky130_fd_sc_hd__or3b_4
X_552_ net120 net66 _296_ VGND VGND VPWR VPWR _064_ sky130_fd_sc_hd__mux2_1
XFILLER_8_157 VGND VGND VPWR VPWR sky130_fd_sc_hd__decap_8
XFILLER_35_278 VGND VGND VPWR VPWR sky130_fd_sc_hd__fill_2
XFILLER_35_223 VGND VGND VPWR VPWR sky130_fd_sc_hd__fill_1
XFILLER_50_237 VGND VGND VPWR VPWR sky130_fd_sc_hd__decap_4
Xhold102 mem\[10\]\[0\] VGND VGND VPWR VPWR net178 sky130_fd_sc_hd__dlygate4sd3_1
Xhold124 mem\[3\]\[1\] VGND VGND VPWR VPWR net200 sky130_fd_sc_hd__dlygate4sd3_1
Xhold113 mem\[7\]\[2\] VGND VGND VPWR VPWR net189 sky130_fd_sc_hd__dlygate4sd3_1
XFILLER_41_204 VGND VGND VPWR VPWR sky130_fd_sc_hd__decap_3
X_604_ net121 net53 _302_ VGND VGND VPWR VPWR _110_ sky130_fd_sc_hd__mux2_1
XFILLER_17_223 VGND VGND VPWR VPWR sky130_fd_sc_hd__fill_1
X_535_ net135 net63 _294_ VGND VGND VPWR VPWR _049_ sky130_fd_sc_hd__mux2_1
X_397_ wr_bin\[1\] _209_ VGND VGND VPWR VPWR wr_gray_next\[0\] sky130_fd_sc_hd__xnor2_1
X_466_ mem\[0\]\[5\] mem\[1\]\[5\] mem\[2\]\[5\] mem\[3\]\[5\] net46 net42 VGND VGND
+ VPWR VPWR _270_ sky130_fd_sc_hd__mux4_1
XFILLER_4_193 VGND VGND VPWR VPWR sky130_fd_sc_hd__decap_3
XFILLER_4_171 VGND VGND VPWR VPWR sky130_fd_sc_hd__fill_1
XFILLER_4_97 VGND VGND VPWR VPWR sky130_fd_sc_hd__decap_4
XTAP_TAPCELL_ROW_2_119 VGND VPWR sky130_fd_sc_hd__tapvpwrvgnd_1
XTAP_TAPCELL_ROW_33_276 VGND VPWR sky130_fd_sc_hd__tapvpwrvgnd_1
XFILLER_48_15 VPWR VGND VPWR VGND sky130_ef_sc_hd__decap_12
X_320_ _137_ _150_ VGND VGND VPWR VPWR _151_ sky130_fd_sc_hd__or2_1
XFILLER_14_226 VGND VGND VPWR VPWR sky130_fd_sc_hd__fill_1
Xfanout63 net15 VGND VGND VPWR VPWR net63 sky130_fd_sc_hd__clkbuf_2
Xfanout52 net21 VGND VGND VPWR VPWR net52 sky130_fd_sc_hd__buf_1
Xfanout41 rd_bin\[2\] VGND VGND VPWR VPWR net41 sky130_fd_sc_hd__clkbuf_2
Xfanout74 net75 VGND VGND VPWR VPWR net74 sky130_fd_sc_hd__buf_2
XFILLER_13_95 VGND VGND VPWR VPWR sky130_fd_sc_hd__fill_1
XFILLER_49_167 VGND VGND VPWR VPWR sky130_fd_sc_hd__fill_1
XFILLER_1_152 VPWR VGND VPWR VGND sky130_ef_sc_hd__decap_12
XTAP_TAPCELL_ROW_47_346 VGND VPWR sky130_fd_sc_hd__tapvpwrvgnd_1
X_518_ net59 net195 _291_ VGND VGND VPWR VPWR _035_ sky130_fd_sc_hd__mux2_1
Xclkload11 clknet_4_12_0_wr_clk VGND VGND VPWR VPWR clkload11/Y sky130_fd_sc_hd__inv_6
XTAP_TAPCELL_ROW_30_257 VGND VPWR sky130_fd_sc_hd__tapvpwrvgnd_1
X_449_ mem\[12\]\[2\] mem\[13\]\[2\] mem\[14\]\[2\] mem\[15\]\[2\] net47 net44 VGND
+ VGND VPWR VPWR _256_ sky130_fd_sc_hd__mux4_1
XPHY_EDGE_ROW_50_Left_101 VGND VGND VPWR VPWR sky130_fd_sc_hd__decap_3
XTAP_TAPCELL_ROW_21_213 VGND VPWR sky130_fd_sc_hd__tapvpwrvgnd_1
Xclkload5 clknet_4_6_0_wr_clk VGND VGND VPWR VPWR clkload5/Y sky130_fd_sc_hd__clkinv_4
XFILLER_50_27 VGND VGND VPWR VPWR sky130_fd_sc_hd__fill_1
XTAP_TAPCELL_ROW_44_327 VGND VPWR sky130_fd_sc_hd__tapvpwrvgnd_1
XFILLER_24_83 VGND VGND VPWR VPWR sky130_fd_sc_hd__fill_1
XFILLER_24_94 VGND VGND VPWR VPWR sky130_fd_sc_hd__decap_6
XFILLER_6_277 VPWR VGND VPWR VGND sky130_ef_sc_hd__decap_12
XFILLER_37_159 VGND VGND VPWR VPWR sky130_fd_sc_hd__fill_1
Xhold39 mem\[1\]\[7\] VGND VGND VPWR VPWR net115 sky130_fd_sc_hd__dlygate4sd3_1
Xhold17 mem\[2\]\[2\] VGND VGND VPWR VPWR net93 sky130_fd_sc_hd__dlygate4sd3_1
Xhold28 mem\[8\]\[2\] VGND VGND VPWR VPWR net104 sky130_fd_sc_hd__dlygate4sd3_1
XFILLER_45_38 VGND VGND VPWR VPWR sky130_fd_sc_hd__fill_1
XPHY_EDGE_ROW_7_Left_58 VGND VGND VPWR VPWR sky130_fd_sc_hd__decap_3
XFILLER_3_225 VPWR VGND VPWR VGND sky130_ef_sc_hd__decap_12
XFILLER_10_85 VGND VGND VPWR VPWR sky130_fd_sc_hd__decap_8
XFILLER_19_148 VPWR VGND VPWR VGND sky130_ef_sc_hd__decap_12
X_783_ net12 wr_gray_sync1\[4\] net72 VGND VGND VPWR VPWR wr_bin_sync\[4\] sky130_fd_sc_hd__dfrtp_2
XFILLER_42_195 VGND VGND VPWR VPWR sky130_fd_sc_hd__fill_1
XFILLER_27_181 VGND VGND VPWR VPWR sky130_fd_sc_hd__decap_8
XFILLER_25_3 VPWR VGND VPWR VGND sky130_ef_sc_hd__decap_12
Xoutput29 net29 VGND VGND VPWR VPWR rd_data[2] sky130_fd_sc_hd__buf_2
XFILLER_21_51 VGND VGND VPWR VPWR sky130_fd_sc_hd__decap_4
XFILLER_47_276 VGND VGND VPWR VPWR sky130_fd_sc_hd__decap_4
X_766_ clknet_4_10_0_wr_clk _116_ VGND VGND VPWR VPWR mem\[4\]\[4\] sky130_fd_sc_hd__dfxtp_1
X_697_ clknet_4_9_0_wr_clk _065_ VGND VGND VPWR VPWR mem\[8\]\[1\] sky130_fd_sc_hd__dfxtp_1
XFILLER_30_110 VPWR VGND VPWR VGND sky130_ef_sc_hd__decap_12
XFILLER_30_154 VGND VGND VPWR VPWR sky130_fd_sc_hd__fill_1
XPHY_EDGE_ROW_5_Right_5 VGND VGND VPWR VPWR sky130_fd_sc_hd__decap_3
XFILLER_21_121 VGND VGND VPWR VPWR sky130_fd_sc_hd__decap_3
XTAP_TAPCELL_ROW_16_190 VGND VPWR sky130_fd_sc_hd__tapvpwrvgnd_1
XTAP_TAPCELL_ROW_8_147 VGND VPWR sky130_fd_sc_hd__tapvpwrvgnd_1
X_551_ _288_ _290_ VGND VGND VPWR VPWR _296_ sky130_fd_sc_hd__nor2_4
X_620_ net56 net185 net35 VGND VGND VPWR VPWR _125_ sky130_fd_sc_hd__mux2_1
XFILLER_44_279 VGND VGND VPWR VPWR sky130_fd_sc_hd__fill_2
XFILLER_8_103 VGND VGND VPWR VPWR sky130_fd_sc_hd__decap_3
XFILLER_16_73 VGND VGND VPWR VPWR sky130_fd_sc_hd__decap_8
X_482_ net34 _283_ net36 VGND VGND VPWR VPWR _007_ sky130_fd_sc_hd__mux2_1
XFILLER_50_216 VGND VGND VPWR VPWR sky130_fd_sc_hd__decap_4
XFILLER_35_235 VGND VGND VPWR VPWR sky130_fd_sc_hd__fill_1
X_749_ net67 rd_bin_next\[3\] net70 VGND VGND VPWR VPWR rd_bin\[3\] sky130_fd_sc_hd__dfrtp_1
Xhold114 mem\[3\]\[4\] VGND VGND VPWR VPWR net190 sky130_fd_sc_hd__dlygate4sd3_1
Xhold103 mem\[9\]\[2\] VGND VGND VPWR VPWR net179 sky130_fd_sc_hd__dlygate4sd3_1
Xhold125 mem\[11\]\[1\] VGND VGND VPWR VPWR net201 sky130_fd_sc_hd__dlygate4sd3_1
XFILLER_26_224 VGND VGND VPWR VPWR sky130_fd_sc_hd__decap_8
XFILLER_26_279 VGND VGND VPWR VPWR sky130_fd_sc_hd__fill_2
XFILLER_1_301 VGND VGND VPWR VPWR sky130_fd_sc_hd__fill_1
XPHY_EDGE_ROW_36_Left_87 VGND VGND VPWR VPWR sky130_fd_sc_hd__decap_3
X_534_ net178 net66 _294_ VGND VGND VPWR VPWR _048_ sky130_fd_sc_hd__mux2_1
X_465_ mem\[4\]\[5\] mem\[5\]\[5\] mem\[6\]\[5\] mem\[7\]\[5\] net46 net42 VGND VGND
+ VPWR VPWR _269_ sky130_fd_sc_hd__mux4_1
X_603_ net98 net55 _302_ VGND VGND VPWR VPWR _109_ sky130_fd_sc_hd__mux2_1
XFILLER_17_246 VGND VGND VPWR VPWR sky130_fd_sc_hd__decap_4
XFILLER_32_205 VPWR VGND VPWR VGND sky130_ef_sc_hd__decap_12
XFILLER_32_227 VPWR VGND VPWR VGND sky130_ef_sc_hd__decap_12
XFILLER_43_93 VGND VGND VPWR VPWR sky130_fd_sc_hd__decap_8
X_396_ _136_ wr_gray_next\[1\] VGND VGND VPWR VPWR _219_ sky130_fd_sc_hd__nand2_1
XFILLER_4_161 VGND VGND VPWR VPWR sky130_fd_sc_hd__fill_1
XFILLER_23_216 VGND VGND VPWR VPWR sky130_fd_sc_hd__decap_4
XFILLER_48_27 VGND VGND VPWR VPWR sky130_fd_sc_hd__fill_1
Xclkbuf_4_7_0_wr_clk clknet_0_wr_clk VGND VGND VPWR VPWR clknet_4_7_0_wr_clk sky130_fd_sc_hd__clkbuf_8
Xfanout53 net20 VGND VGND VPWR VPWR net53 sky130_fd_sc_hd__clkbuf_2
Xfanout75 net76 VGND VGND VPWR VPWR net75 sky130_fd_sc_hd__buf_2
XFILLER_13_30 VGND VGND VPWR VPWR sky130_fd_sc_hd__fill_1
Xfanout42 net43 VGND VGND VPWR VPWR net42 sky130_fd_sc_hd__clkbuf_4
Xfanout64 net15 VGND VGND VPWR VPWR net64 sky130_fd_sc_hd__buf_1
XFILLER_22_293 VGND VGND VPWR VPWR sky130_fd_sc_hd__decap_8
XFILLER_49_113 VPWR VGND VPWR VGND sky130_ef_sc_hd__decap_12
XFILLER_38_93 VGND VGND VPWR VPWR sky130_fd_sc_hd__decap_8
XFILLER_1_164 VGND VGND VPWR VPWR sky130_fd_sc_hd__decap_4
X_517_ net61 net206 _291_ VGND VGND VPWR VPWR _034_ sky130_fd_sc_hd__mux2_1
X_448_ mem\[0\]\[2\] mem\[1\]\[2\] mem\[2\]\[2\] mem\[3\]\[2\] net50 net44 VGND VGND
+ VPWR VPWR _255_ sky130_fd_sc_hd__mux4_1
X_379_ net26 net22 VGND VGND VPWR VPWR _208_ sky130_fd_sc_hd__and2b_1
Xclkload12 clknet_4_13_0_wr_clk VGND VGND VPWR VPWR clkload12/Y sky130_fd_sc_hd__inv_6
XTAP_TAPCELL_ROW_30_258 VGND VPWR sky130_fd_sc_hd__tapvpwrvgnd_1
XTAP_TAPCELL_ROW_21_214 VGND VPWR sky130_fd_sc_hd__tapvpwrvgnd_1
Xclkload6 clknet_4_7_0_wr_clk VGND VGND VPWR VPWR clkload6/Y sky130_fd_sc_hd__bufinv_16
XTAP_TAPCELL_ROW_44_328 VGND VPWR sky130_fd_sc_hd__tapvpwrvgnd_1
XFILLER_10_241 VGND VGND VPWR VPWR sky130_fd_sc_hd__decap_8
XFILLER_49_81 VPWR VGND VPWR VGND sky130_ef_sc_hd__decap_12
XFILLER_6_289 VPWR VGND VPWR VGND sky130_ef_sc_hd__decap_12
XPHY_EDGE_ROW_39_Left_90 VGND VGND VPWR VPWR sky130_fd_sc_hd__decap_3
XPHY_EDGE_ROW_23_Left_74 VGND VGND VPWR VPWR sky130_fd_sc_hd__decap_3
Xhold29 mem\[2\]\[5\] VGND VGND VPWR VPWR net105 sky130_fd_sc_hd__dlygate4sd3_1
Xhold18 mem\[12\]\[3\] VGND VGND VPWR VPWR net94 sky130_fd_sc_hd__dlygate4sd3_1
XFILLER_29_29 VGND VGND VPWR VPWR sky130_fd_sc_hd__decap_3
XFILLER_3_237 VPWR VGND VPWR VGND sky130_ef_sc_hd__decap_12
XFILLER_10_64 VGND VGND VPWR VPWR sky130_fd_sc_hd__decap_3
XFILLER_10_75 VGND VGND VPWR VPWR sky130_fd_sc_hd__decap_8
X_782_ net12 wr_gray_sync1\[3\] net72 VGND VGND VPWR VPWR wr_gray_sync2\[3\] sky130_fd_sc_hd__dfrtp_2
XFILLER_42_163 VGND VGND VPWR VPWR sky130_fd_sc_hd__decap_6
XFILLER_42_141 VGND VGND VPWR VPWR sky130_fd_sc_hd__fill_1
XFILLER_18_3 VGND VGND VPWR VPWR sky130_fd_sc_hd__fill_1
XFILLER_24_141 VGND VGND VPWR VPWR sky130_fd_sc_hd__fill_2
X_696_ clknet_4_13_0_wr_clk _064_ VGND VGND VPWR VPWR mem\[8\]\[0\] sky130_fd_sc_hd__dfxtp_1
X_765_ clknet_4_3_0_wr_clk _115_ VGND VGND VPWR VPWR mem\[4\]\[3\] sky130_fd_sc_hd__dfxtp_1
XFILLER_30_122 VPWR VGND VPWR VGND sky130_ef_sc_hd__decap_12
XFILLER_38_211 VPWR VGND VPWR VGND sky130_ef_sc_hd__decap_12
XTAP_TAPCELL_ROW_16_191 VGND VPWR sky130_fd_sc_hd__tapvpwrvgnd_1
XFILLER_21_166 VGND VGND VPWR VPWR sky130_fd_sc_hd__fill_2
XTAP_TAPCELL_ROW_8_148 VGND VPWR sky130_fd_sc_hd__tapvpwrvgnd_1
XPHY_EDGE_ROW_10_Left_61 VGND VGND VPWR VPWR sky130_fd_sc_hd__decap_3
X_550_ net90 net52 _295_ VGND VGND VPWR VPWR _063_ sky130_fd_sc_hd__mux2_1
X_481_ _280_ _282_ _279_ _281_ net39 net40 VGND VGND VPWR VPWR _283_ sky130_fd_sc_hd__mux4_1
XPHY_EDGE_ROW_11_Right_11 VGND VGND VPWR VPWR sky130_fd_sc_hd__decap_3
XFILLER_12_155 VGND VGND VPWR VPWR sky130_fd_sc_hd__decap_6
XFILLER_16_85 VPWR VGND VPWR VGND sky130_ef_sc_hd__decap_12
XPHY_EDGE_ROW_20_Right_20 VGND VGND VPWR VPWR sky130_fd_sc_hd__decap_3
XFILLER_35_225 VGND VGND VPWR VPWR sky130_fd_sc_hd__decap_3
X_679_ clknet_4_1_0_wr_clk _047_ VGND VGND VPWR VPWR mem\[1\]\[7\] sky130_fd_sc_hd__dfxtp_1
X_748_ net67 rd_bin_next\[2\] net70 VGND VGND VPWR VPWR rd_bin\[2\] sky130_fd_sc_hd__dfrtp_1
Xhold104 mem\[7\]\[0\] VGND VGND VPWR VPWR net180 sky130_fd_sc_hd__dlygate4sd3_1
XTAP_TAPCELL_ROW_13_172 VGND VPWR sky130_fd_sc_hd__tapvpwrvgnd_1
Xhold126 mem\[7\]\[7\] VGND VGND VPWR VPWR net202 sky130_fd_sc_hd__dlygate4sd3_1
Xhold115 mem\[3\]\[2\] VGND VGND VPWR VPWR net191 sky130_fd_sc_hd__dlygate4sd3_1
XFILLER_26_203 VGND VGND VPWR VPWR sky130_fd_sc_hd__fill_1
XFILLER_41_228 VPWR VGND VPWR VGND sky130_ef_sc_hd__decap_12
X_602_ net209 net58 _302_ VGND VGND VPWR VPWR _108_ sky130_fd_sc_hd__mux2_1
X_533_ _284_ _290_ VGND VGND VPWR VPWR _294_ sky130_fd_sc_hd__nor2_4
X_464_ net31 _268_ net36 VGND VGND VPWR VPWR _004_ sky130_fd_sc_hd__mux2_1
XFILLER_17_225 VGND VGND VPWR VPWR sky130_fd_sc_hd__fill_1
XTAP_TAPCELL_ROW_27_242 VGND VPWR sky130_fd_sc_hd__tapvpwrvgnd_1
XFILLER_32_217 VGND VGND VPWR VPWR sky130_fd_sc_hd__fill_2
XFILLER_32_239 VPWR VGND VPWR VGND sky130_ef_sc_hd__decap_12
X_395_ _136_ wr_gray_next\[1\] VGND VGND VPWR VPWR _218_ sky130_fd_sc_hd__nor2_1
XFILLER_31_261 VPWR VGND VPWR VGND sky130_ef_sc_hd__decap_12
Xfanout65 net14 VGND VGND VPWR VPWR net65 sky130_fd_sc_hd__clkbuf_2
Xfanout54 net20 VGND VGND VPWR VPWR net54 sky130_fd_sc_hd__buf_1
Xfanout76 net11 VGND VGND VPWR VPWR net76 sky130_fd_sc_hd__buf_2
Xfanout43 rd_bin\[1\] VGND VGND VPWR VPWR net43 sky130_fd_sc_hd__clkbuf_4
XFILLER_49_169 VPWR VGND VPWR VGND sky130_ef_sc_hd__decap_12
XFILLER_49_125 VPWR VGND VPWR VGND sky130_ef_sc_hd__decap_12
XFILLER_38_50 VGND VGND VPWR VPWR sky130_fd_sc_hd__decap_6
X_378_ _195_ _207_ _194_ VGND VGND VPWR VPWR aempty_next sky130_fd_sc_hd__a21oi_1
X_516_ net63 net201 _291_ VGND VGND VPWR VPWR _033_ sky130_fd_sc_hd__mux2_1
X_447_ mem\[4\]\[2\] mem\[5\]\[2\] mem\[6\]\[2\] mem\[7\]\[2\] net47 net44 VGND VGND
+ VPWR VPWR _254_ sky130_fd_sc_hd__mux4_1
XTAP_TAPCELL_ROW_30_259 VGND VPWR sky130_fd_sc_hd__tapvpwrvgnd_1
Xclkload13 clknet_4_14_0_wr_clk VGND VGND VPWR VPWR clkload13/Y sky130_fd_sc_hd__inv_8
XFILLER_48_3 VPWR VGND VPWR VGND sky130_ef_sc_hd__decap_12
XFILLER_34_19 VGND VGND VPWR VPWR sky130_fd_sc_hd__fill_1
XFILLER_50_29 VPWR VGND VPWR VGND sky130_ef_sc_hd__decap_12
XTAP_TAPCELL_ROW_21_215 VGND VPWR sky130_fd_sc_hd__tapvpwrvgnd_1
Xclkload7 clknet_4_8_0_wr_clk VGND VGND VPWR VPWR clkload7/Y sky130_fd_sc_hd__inv_6
XTAP_TAPCELL_ROW_44_329 VGND VPWR sky130_fd_sc_hd__tapvpwrvgnd_1
XFILLER_42_301 VGND VGND VPWR VPWR sky130_fd_sc_hd__fill_1
XFILLER_24_85 VGND VGND VPWR VPWR sky130_fd_sc_hd__fill_1
XFILLER_10_253 VPWR VGND VPWR VGND sky130_ef_sc_hd__decap_12
XFILLER_49_93 VPWR VGND VPWR VGND sky130_ef_sc_hd__decap_12
XFILLER_33_301 VGND VGND VPWR VPWR sky130_fd_sc_hd__fill_1
XPHY_EDGE_ROW_49_Right_49 VGND VGND VPWR VPWR sky130_fd_sc_hd__decap_3
XFILLER_45_18 VPWR VGND VPWR VGND sky130_ef_sc_hd__decap_12
Xhold19 mem\[4\]\[3\] VGND VGND VPWR VPWR net95 sky130_fd_sc_hd__dlygate4sd3_1
XPHY_EDGE_ROW_40_Left_91 VGND VGND VPWR VPWR sky130_fd_sc_hd__decap_3
XFILLER_3_249 VPWR VGND VPWR VGND sky130_ef_sc_hd__decap_12
X_781_ net69 wr_gray_sync1\[2\] net72 VGND VGND VPWR VPWR wr_gray_sync2\[2\] sky130_fd_sc_hd__dfrtp_1
XTAP_TAPCELL_ROW_40_310 VGND VPWR sky130_fd_sc_hd__tapvpwrvgnd_1
XFILLER_33_197 VPWR VGND VPWR VGND sky130_ef_sc_hd__decap_12
X_764_ clknet_4_4_0_wr_clk _114_ VGND VGND VPWR VPWR mem\[4\]\[2\] sky130_fd_sc_hd__dfxtp_1
XFILLER_46_83 VGND VGND VPWR VPWR sky130_fd_sc_hd__fill_1
XFILLER_15_175 VGND VGND VPWR VPWR sky130_fd_sc_hd__fill_1
X_695_ clknet_4_3_0_wr_clk _063_ VGND VGND VPWR VPWR mem\[0\]\[7\] sky130_fd_sc_hd__dfxtp_1
XFILLER_7_55 VGND VGND VPWR VPWR sky130_fd_sc_hd__fill_1
XFILLER_30_134 VGND VGND VPWR VPWR sky130_fd_sc_hd__decap_6
XFILLER_38_223 VGND VGND VPWR VPWR sky130_fd_sc_hd__fill_2
XFILLER_21_178 VGND VGND VPWR VPWR sky130_fd_sc_hd__decap_6
XTAP_TAPCELL_ROW_8_149 VGND VPWR sky130_fd_sc_hd__tapvpwrvgnd_1
XFILLER_16_64 VGND VGND VPWR VPWR sky130_fd_sc_hd__fill_1
X_480_ mem\[8\]\[7\] mem\[9\]\[7\] mem\[10\]\[7\] mem\[11\]\[7\] net46 net42 VGND
+ VGND VPWR VPWR _282_ sky130_fd_sc_hd__mux4_1
XFILLER_12_145 VGND VGND VPWR VPWR sky130_fd_sc_hd__fill_1
XFILLER_16_97 VGND VGND VPWR VPWR sky130_fd_sc_hd__decap_6
XFILLER_32_74 VGND VGND VPWR VPWR sky130_fd_sc_hd__fill_1
XFILLER_32_85 VGND VGND VPWR VPWR sky130_fd_sc_hd__decap_6
X_747_ net67 rd_bin_next\[1\] net70 VGND VGND VPWR VPWR rd_bin\[1\] sky130_fd_sc_hd__dfrtp_1
XFILLER_43_281 VPWR VGND VPWR VGND sky130_ef_sc_hd__decap_12
X_678_ clknet_4_7_0_wr_clk _046_ VGND VGND VPWR VPWR mem\[1\]\[6\] sky130_fd_sc_hd__dfxtp_1
Xhold127 mem\[4\]\[0\] VGND VGND VPWR VPWR net203 sky130_fd_sc_hd__dlygate4sd3_1
XFILLER_7_193 VGND VGND VPWR VPWR sky130_fd_sc_hd__decap_3
Xhold105 mem\[2\]\[4\] VGND VGND VPWR VPWR net181 sky130_fd_sc_hd__dlygate4sd3_1
XTAP_TAPCELL_ROW_13_173 VGND VPWR sky130_fd_sc_hd__tapvpwrvgnd_1
Xhold116 mem\[9\]\[7\] VGND VGND VPWR VPWR net192 sky130_fd_sc_hd__dlygate4sd3_1
XTAP_TAPCELL_ROW_36_287 VGND VPWR sky130_fd_sc_hd__tapvpwrvgnd_1
XTAP_TAPCELL_ROW_4_130 VGND VPWR sky130_fd_sc_hd__tapvpwrvgnd_1
X_601_ net132 net60 _302_ VGND VGND VPWR VPWR _107_ sky130_fd_sc_hd__mux2_1
X_394_ net38 _212_ VGND VGND VPWR VPWR wr_gray_next\[1\] sky130_fd_sc_hd__xnor2_1
X_463_ _265_ _267_ _264_ _266_ net39 net40 VGND VGND VPWR VPWR _268_ sky130_fd_sc_hd__mux4_1
X_532_ net115 net52 _293_ VGND VGND VPWR VPWR _047_ sky130_fd_sc_hd__mux2_1
XFILLER_25_270 VGND VGND VPWR VPWR sky130_fd_sc_hd__decap_8
XFILLER_25_281 VGND VGND VPWR VPWR sky130_fd_sc_hd__fill_1
XTAP_TAPCELL_ROW_27_243 VGND VPWR sky130_fd_sc_hd__tapvpwrvgnd_1
XFILLER_40_273 VGND VGND VPWR VPWR sky130_fd_sc_hd__decap_6
XFILLER_4_141 VPWR VGND VPWR VGND sky130_ef_sc_hd__decap_12
XFILLER_4_67 VPWR VGND VPWR VGND sky130_ef_sc_hd__decap_12
XFILLER_31_273 VGND VGND VPWR VPWR sky130_fd_sc_hd__decap_6
XFILLER_48_29 VPWR VGND VPWR VGND sky130_ef_sc_hd__decap_12
Xfanout55 net19 VGND VGND VPWR VPWR net55 sky130_fd_sc_hd__clkbuf_2
Xfanout44 net45 VGND VGND VPWR VPWR net44 sky130_fd_sc_hd__clkbuf_4
Xfanout66 net14 VGND VGND VPWR VPWR net66 sky130_fd_sc_hd__buf_1
XFILLER_49_137 VPWR VGND VPWR VGND sky130_ef_sc_hd__decap_12
XFILLER_8_3 VPWR VGND VPWR VGND sky130_ef_sc_hd__decap_12
XFILLER_1_111 VGND VGND VPWR VPWR sky130_fd_sc_hd__fill_1
X_515_ net66 net182 _291_ VGND VGND VPWR VPWR _032_ sky130_fd_sc_hd__mux2_1
X_377_ _144_ _189_ _196_ _197_ _206_ VGND VGND VPWR VPWR _207_ sky130_fd_sc_hd__a32o_1
X_446_ net28 _253_ net36 VGND VGND VPWR VPWR _001_ sky130_fd_sc_hd__mux2_1
Xclkload14 clknet_4_15_0_wr_clk VGND VGND VPWR VPWR clkload14/Y sky130_fd_sc_hd__inv_6
XTAP_TAPCELL_ROW_21_216 VGND VPWR sky130_fd_sc_hd__tapvpwrvgnd_1
Xclkload8 clknet_4_9_0_wr_clk VGND VGND VPWR VPWR clkload8/Y sky130_fd_sc_hd__clkinvlp_4
XFILLER_39_181 VGND VGND VPWR VPWR sky130_fd_sc_hd__fill_1
XFILLER_40_85 VPWR VGND VPWR VGND sky130_ef_sc_hd__decap_12
XFILLER_10_265 VPWR VGND VPWR VGND sky130_ef_sc_hd__decap_12
XFILLER_10_298 VGND VGND VPWR VPWR sky130_fd_sc_hd__fill_1
XFILLER_37_129 VPWR VGND VPWR VGND sky130_ef_sc_hd__decap_12
XFILLER_45_184 VGND VGND VPWR VPWR sky130_fd_sc_hd__fill_2
XFILLER_45_140 VGND VGND VPWR VPWR sky130_fd_sc_hd__fill_1
XFILLER_1_57 VPWR VGND VPWR VGND sky130_ef_sc_hd__decap_12
X_429_ _215_ net35 VGND VGND VPWR VPWR wr_bin_next\[3\] sky130_fd_sc_hd__and2b_1
Xinput1 aempty_threshold[0] VGND VGND VPWR VPWR net1 sky130_fd_sc_hd__clkbuf_1
XFILLER_36_184 VGND VGND VPWR VPWR sky130_fd_sc_hd__fill_1
X_780_ net68 wr_gray_sync1\[1\] net70 VGND VGND VPWR VPWR wr_gray_sync2\[1\] sky130_fd_sc_hd__dfrtp_1
XTAP_TAPCELL_ROW_40_311 VGND VPWR sky130_fd_sc_hd__tapvpwrvgnd_1
XFILLER_18_195 VGND VGND VPWR VPWR sky130_fd_sc_hd__fill_1
XFILLER_33_187 VGND VGND VPWR VPWR sky130_fd_sc_hd__fill_1
XFILLER_0_209 VPWR VGND VPWR VGND sky130_ef_sc_hd__decap_12
XFILLER_21_21 VGND VGND VPWR VPWR sky130_fd_sc_hd__decap_6
XFILLER_24_187 VGND VGND VPWR VPWR sky130_fd_sc_hd__fill_1
X_694_ clknet_4_7_0_wr_clk _062_ VGND VGND VPWR VPWR mem\[0\]\[6\] sky130_fd_sc_hd__dfxtp_1
X_763_ clknet_4_8_0_wr_clk _113_ VGND VGND VPWR VPWR mem\[4\]\[1\] sky130_fd_sc_hd__dfxtp_1
XFILLER_23_3 VGND VGND VPWR VPWR sky130_fd_sc_hd__fill_2
XFILLER_21_113 VGND VGND VPWR VPWR sky130_fd_sc_hd__decap_8
XFILLER_29_279 VGND VGND VPWR VPWR sky130_fd_sc_hd__fill_1
XFILLER_16_21 VGND VGND VPWR VPWR sky130_fd_sc_hd__decap_6
XFILLER_4_301 VGND VGND VPWR VPWR sky130_fd_sc_hd__fill_1
XFILLER_20_190 VGND VGND VPWR VPWR sky130_fd_sc_hd__decap_6
X_677_ clknet_4_2_0_wr_clk _045_ VGND VGND VPWR VPWR mem\[1\]\[5\] sky130_fd_sc_hd__dfxtp_1
X_746_ net67 rd_bin_next\[0\] net71 VGND VGND VPWR VPWR rd_bin\[0\] sky130_fd_sc_hd__dfrtp_1
XFILLER_43_293 VGND VGND VPWR VPWR sky130_fd_sc_hd__decap_8
XTAP_TAPCELL_ROW_13_174 VGND VPWR sky130_fd_sc_hd__tapvpwrvgnd_1
Xhold106 mem\[11\]\[0\] VGND VGND VPWR VPWR net182 sky130_fd_sc_hd__dlygate4sd3_1
Xhold117 mem\[1\]\[4\] VGND VGND VPWR VPWR net193 sky130_fd_sc_hd__dlygate4sd3_1
XPHY_EDGE_ROW_9_Right_9 VGND VGND VPWR VPWR sky130_fd_sc_hd__decap_3
Xhold128 mem\[15\]\[7\] VGND VGND VPWR VPWR net204 sky130_fd_sc_hd__dlygate4sd3_1
XTAP_TAPCELL_ROW_36_288 VGND VPWR sky130_fd_sc_hd__tapvpwrvgnd_1
XTAP_TAPCELL_ROW_4_131 VGND VPWR sky130_fd_sc_hd__tapvpwrvgnd_1
X_600_ net168 net61 _302_ VGND VGND VPWR VPWR _106_ sky130_fd_sc_hd__mux2_1
X_531_ net125 net54 _293_ VGND VGND VPWR VPWR _046_ sky130_fd_sc_hd__mux2_1
XFILLER_43_52 VGND VGND VPWR VPWR sky130_fd_sc_hd__decap_4
X_393_ full_compare\[2\] wr_gray_next\[2\] VGND VGND VPWR VPWR _217_ sky130_fd_sc_hd__xor2_1
Xclkbuf_4_12_0_wr_clk clknet_0_wr_clk VGND VGND VPWR VPWR clknet_4_12_0_wr_clk sky130_fd_sc_hd__clkbuf_8
X_462_ mem\[8\]\[4\] mem\[9\]\[4\] mem\[10\]\[4\] mem\[11\]\[4\] net48 net43 VGND
+ VGND VPWR VPWR _267_ sky130_fd_sc_hd__mux4_1
XTAP_TAPCELL_ROW_27_244 VGND VPWR sky130_fd_sc_hd__tapvpwrvgnd_1
XFILLER_4_153 VGND VGND VPWR VPWR sky130_fd_sc_hd__decap_8
XFILLER_4_197 VPWR VGND VPWR VGND sky130_ef_sc_hd__decap_12
XFILLER_4_79 VGND VGND VPWR VPWR sky130_fd_sc_hd__decap_4
XTAP_TAPCELL_ROW_18_200 VGND VPWR sky130_fd_sc_hd__tapvpwrvgnd_1
X_729_ clknet_4_9_0_wr_clk _097_ VGND VGND VPWR VPWR mem\[3\]\[1\] sky130_fd_sc_hd__dfxtp_1
XTAP_TAPCELL_ROW_1_112 VGND VPWR sky130_fd_sc_hd__tapvpwrvgnd_1
Xfanout56 net19 VGND VGND VPWR VPWR net56 sky130_fd_sc_hd__buf_1
Xfanout67 net68 VGND VGND VPWR VPWR net67 sky130_fd_sc_hd__clkbuf_2
Xfanout45 rd_bin\[1\] VGND VGND VPWR VPWR net45 sky130_fd_sc_hd__buf_2
XFILLER_49_149 VPWR VGND VPWR VGND sky130_ef_sc_hd__decap_12
XFILLER_49_105 VGND VGND VPWR VPWR sky130_fd_sc_hd__decap_6
XFILLER_1_178 VGND VGND VPWR VPWR sky130_fd_sc_hd__fill_1
X_514_ net38 _211_ net37 VGND VGND VPWR VPWR _291_ sky130_fd_sc_hd__nand3b_4
X_376_ _200_ _205_ _199_ VGND VGND VPWR VPWR _206_ sky130_fd_sc_hd__o21ai_1
XFILLER_13_285 VPWR VGND VPWR VGND sky130_ef_sc_hd__decap_12
X_445_ _249_ _252_ rd_bin\[3\] VGND VGND VPWR VPWR _253_ sky130_fd_sc_hd__mux2_1
Xclkload9 clknet_4_10_0_wr_clk VGND VGND VPWR VPWR clkload9/X sky130_fd_sc_hd__clkbuf_8
XFILLER_40_97 VGND VGND VPWR VPWR sky130_fd_sc_hd__decap_8
XFILLER_49_51 VGND VGND VPWR VPWR sky130_fd_sc_hd__decap_4
XFILLER_1_69 VPWR VGND VPWR VGND sky130_ef_sc_hd__decap_12
X_428_ _238_ _240_ _241_ VGND VGND VPWR VPWR empty_next sky130_fd_sc_hd__and3_1
X_359_ _180_ _188_ _178_ VGND VGND VPWR VPWR _189_ sky130_fd_sc_hd__o21ai_2
XFILLER_5_281 VPWR VGND VPWR VGND sky130_ef_sc_hd__decap_12
XFILLER_36_141 VGND VGND VPWR VPWR sky130_fd_sc_hd__decap_4
Xinput2 aempty_threshold[1] VGND VGND VPWR VPWR net2 sky130_fd_sc_hd__clkbuf_1
XFILLER_10_45 VGND VGND VPWR VPWR sky130_fd_sc_hd__decap_3
XFILLER_10_56 VGND VGND VPWR VPWR sky130_fd_sc_hd__decap_8
Xclkbuf_4_0_0_wr_clk clknet_0_wr_clk VGND VGND VPWR VPWR clknet_4_0_0_wr_clk sky130_fd_sc_hd__clkbuf_8
XFILLER_2_251 VGND VGND VPWR VPWR sky130_fd_sc_hd__fill_1
XPHY_EDGE_ROW_27_Left_78 VGND VGND VPWR VPWR sky130_fd_sc_hd__decap_3
XFILLER_18_141 VPWR VGND VPWR VGND sky130_ef_sc_hd__decap_12
XFILLER_33_155 VPWR VGND VPWR VGND sky130_ef_sc_hd__decap_12
XFILLER_21_55 VGND VGND VPWR VPWR sky130_fd_sc_hd__fill_1
XFILLER_21_66 VGND VGND VPWR VPWR sky130_fd_sc_hd__decap_8
XFILLER_47_225 VGND VGND VPWR VPWR sky130_fd_sc_hd__fill_1
XFILLER_46_85 VPWR VGND VPWR VGND sky130_ef_sc_hd__decap_12
XFILLER_46_41 VPWR VGND VPWR VGND sky130_ef_sc_hd__decap_12
X_693_ clknet_4_2_0_wr_clk _061_ VGND VGND VPWR VPWR mem\[0\]\[5\] sky130_fd_sc_hd__dfxtp_1
X_762_ clknet_4_6_0_wr_clk _112_ VGND VGND VPWR VPWR mem\[4\]\[0\] sky130_fd_sc_hd__dfxtp_1
XFILLER_7_57 VGND VGND VPWR VPWR sky130_fd_sc_hd__decap_4
XFILLER_16_3 VGND VGND VPWR VPWR sky130_fd_sc_hd__fill_2
XFILLER_46_291 VGND VGND VPWR VPWR sky130_fd_sc_hd__decap_8
XFILLER_38_247 VGND VGND VPWR VPWR sky130_fd_sc_hd__decap_4
XFILLER_29_225 VPWR VGND VPWR VGND sky130_ef_sc_hd__decap_12
XFILLER_44_239 VGND VGND VPWR VPWR sky130_fd_sc_hd__fill_1
XFILLER_50_209 VGND VGND VPWR VPWR sky130_fd_sc_hd__decap_4
X_676_ clknet_4_10_0_wr_clk _044_ VGND VGND VPWR VPWR mem\[1\]\[4\] sky130_fd_sc_hd__dfxtp_1
X_745_ net67 aempty_next net71 VGND VGND VPWR VPWR net23 sky130_fd_sc_hd__dfstp_1
XTAP_TAPCELL_ROW_13_175 VGND VPWR sky130_fd_sc_hd__tapvpwrvgnd_1
Xhold118 mem\[7\]\[5\] VGND VGND VPWR VPWR net194 sky130_fd_sc_hd__dlygate4sd3_1
Xhold129 mem\[7\]\[4\] VGND VGND VPWR VPWR net205 sky130_fd_sc_hd__dlygate4sd3_1
Xhold107 mem\[13\]\[1\] VGND VGND VPWR VPWR net183 sky130_fd_sc_hd__dlygate4sd3_1
XTAP_TAPCELL_ROW_36_289 VGND VPWR sky130_fd_sc_hd__tapvpwrvgnd_1
XPHY_EDGE_ROW_14_Left_65 VGND VGND VPWR VPWR sky130_fd_sc_hd__decap_3
X_530_ net150 net56 _293_ VGND VGND VPWR VPWR _045_ sky130_fd_sc_hd__mux2_1
X_461_ mem\[12\]\[4\] mem\[13\]\[4\] mem\[14\]\[4\] mem\[15\]\[4\] net48 rd_bin\[1\]
+ VGND VGND VPWR VPWR _266_ sky130_fd_sc_hd__mux4_1
XFILLER_17_217 VGND VGND VPWR VPWR sky130_fd_sc_hd__decap_6
XFILLER_27_87 VGND VGND VPWR VPWR sky130_fd_sc_hd__decap_8
XTAP_TAPCELL_ROW_27_245 VGND VPWR sky130_fd_sc_hd__tapvpwrvgnd_1
XFILLER_40_253 VGND VGND VPWR VPWR sky130_fd_sc_hd__decap_6
X_392_ net37 _213_ VGND VGND VPWR VPWR wr_gray_next\[2\] sky130_fd_sc_hd__xnor2_1
X_728_ clknet_4_6_0_wr_clk _096_ VGND VGND VPWR VPWR mem\[3\]\[0\] sky130_fd_sc_hd__dfxtp_1
X_659_ clknet_4_3_0_wr_clk _027_ VGND VGND VPWR VPWR mem\[12\]\[3\] sky130_fd_sc_hd__dfxtp_1
XTAP_TAPCELL_ROW_18_201 VGND VPWR sky130_fd_sc_hd__tapvpwrvgnd_1
XTAP_TAPCELL_ROW_1_113 VGND VPWR sky130_fd_sc_hd__tapvpwrvgnd_1
Xfanout35 _222_ VGND VGND VPWR VPWR net35 sky130_fd_sc_hd__buf_4
Xfanout57 net18 VGND VGND VPWR VPWR net57 sky130_fd_sc_hd__clkbuf_2
Xfanout46 net50 VGND VGND VPWR VPWR net46 sky130_fd_sc_hd__buf_4
Xfanout68 net12 VGND VGND VPWR VPWR net68 sky130_fd_sc_hd__buf_2
XFILLER_22_253 VGND VGND VPWR VPWR sky130_fd_sc_hd__fill_1
XTAP_TAPCELL_ROW_32_270 VGND VPWR sky130_fd_sc_hd__tapvpwrvgnd_1
XFILLER_1_113 VGND VGND VPWR VPWR sky130_fd_sc_hd__fill_2
X_513_ net38 net37 VGND VGND VPWR VPWR _290_ sky130_fd_sc_hd__nand2b_2
X_444_ _251_ _250_ net41 VGND VGND VPWR VPWR _252_ sky130_fd_sc_hd__mux2_1
XFILLER_9_279 VGND VGND VPWR VPWR sky130_fd_sc_hd__fill_1
X_375_ net1 _203_ _204_ _202_ VGND VGND VPWR VPWR _205_ sky130_fd_sc_hd__o31a_1
XFILLER_13_297 VGND VGND VPWR VPWR sky130_fd_sc_hd__fill_2
XTAP_TAPCELL_ROW_46_340 VGND VPWR sky130_fd_sc_hd__tapvpwrvgnd_1
XFILLER_36_301 VGND VGND VPWR VPWR sky130_fd_sc_hd__fill_1
XFILLER_5_90 VPWR VGND VPWR VGND sky130_ef_sc_hd__decap_12
XFILLER_40_76 VGND VGND VPWR VPWR sky130_fd_sc_hd__decap_8
XFILLER_1_15 VPWR VGND VPWR VGND sky130_ef_sc_hd__decap_12
X_358_ _182_ _185_ _187_ VGND VGND VPWR VPWR _188_ sky130_fd_sc_hd__o21ba_1
X_427_ wr_gray_sync2\[2\] rd_gray_next\[2\] VGND VGND VPWR VPWR _241_ sky130_fd_sc_hd__xnor2_1
XFILLER_46_3 VPWR VGND VPWR VGND sky130_ef_sc_hd__decap_12
XFILLER_5_293 VGND VGND VPWR VPWR sky130_fd_sc_hd__decap_8
XPHY_EDGE_ROW_18_Right_18 VGND VGND VPWR VPWR sky130_fd_sc_hd__decap_3
XFILLER_28_109 VGND VGND VPWR VPWR sky130_fd_sc_hd__decap_8
Xinput3 aempty_threshold[2] VGND VGND VPWR VPWR net3 sky130_fd_sc_hd__clkbuf_1
XPHY_EDGE_ROW_27_Right_27 VGND VGND VPWR VPWR sky130_fd_sc_hd__decap_3
XPHY_EDGE_ROW_36_Right_36 VGND VGND VPWR VPWR sky130_fd_sc_hd__decap_3
XFILLER_10_24 VGND VGND VPWR VPWR sky130_fd_sc_hd__decap_4
XPHY_EDGE_ROW_45_Right_45 VGND VGND VPWR VPWR sky130_fd_sc_hd__decap_3
XPHY_EDGE_ROW_2_Left_53 VGND VGND VPWR VPWR sky130_fd_sc_hd__decap_3
XFILLER_18_153 VPWR VGND VPWR VGND sky130_ef_sc_hd__decap_12
XFILLER_33_167 VGND VGND VPWR VPWR sky130_fd_sc_hd__fill_1
XPHY_EDGE_ROW_44_Left_95 VGND VGND VPWR VPWR sky130_fd_sc_hd__decap_3
X_761_ clknet_4_14_0_wr_clk wr_bin_next\[4\] net72 VGND VGND VPWR VPWR wr_bin\[4\]
+ sky130_fd_sc_hd__dfrtp_4
XFILLER_47_215 VGND VGND VPWR VPWR sky130_fd_sc_hd__fill_2
XFILLER_46_97 VGND VGND VPWR VPWR sky130_fd_sc_hd__decap_6
XFILLER_46_53 VPWR VGND VPWR VGND sky130_ef_sc_hd__decap_12
X_692_ clknet_4_10_0_wr_clk _060_ VGND VGND VPWR VPWR mem\[0\]\[4\] sky130_fd_sc_hd__dfxtp_1
XFILLER_29_237 VPWR VGND VPWR VGND sky130_ef_sc_hd__decap_12
XPHY_EDGE_ROW_0_Right_0 VGND VGND VPWR VPWR sky130_fd_sc_hd__decap_3
XFILLER_12_137 VGND VGND VPWR VPWR sky130_fd_sc_hd__decap_3
XFILLER_16_56 VGND VGND VPWR VPWR sky130_fd_sc_hd__decap_8
X_744_ clknet_4_1_0_wr_clk _111_ VGND VGND VPWR VPWR mem\[5\]\[7\] sky130_fd_sc_hd__dfxtp_1
X_675_ clknet_4_10_0_wr_clk _043_ VGND VGND VPWR VPWR mem\[1\]\[3\] sky130_fd_sc_hd__dfxtp_1
XFILLER_28_281 VPWR VGND VPWR VGND sky130_ef_sc_hd__decap_12
XTAP_TAPCELL_ROW_13_176 VGND VPWR sky130_fd_sc_hd__tapvpwrvgnd_1
Xhold108 mem\[14\]\[2\] VGND VGND VPWR VPWR net184 sky130_fd_sc_hd__dlygate4sd3_1
Xhold119 mem\[11\]\[3\] VGND VGND VPWR VPWR net195 sky130_fd_sc_hd__dlygate4sd3_1
XFILLER_19_281 VPWR VGND VPWR VGND sky130_ef_sc_hd__decap_12
X_391_ rd_gray_sync2\[3\] wr_gray_next\[3\] VGND VGND VPWR VPWR _216_ sky130_fd_sc_hd__xnor2_1
X_460_ mem\[0\]\[4\] mem\[1\]\[4\] mem\[2\]\[4\] mem\[3\]\[4\] net48 net43 VGND VGND
+ VPWR VPWR _265_ sky130_fd_sc_hd__mux4_1
XFILLER_27_55 VGND VGND VPWR VPWR sky130_fd_sc_hd__fill_1
XTAP_TAPCELL_ROW_27_246 VGND VPWR sky130_fd_sc_hd__tapvpwrvgnd_1
XTAP_TAPCELL_ROW_10_157 VGND VPWR sky130_fd_sc_hd__tapvpwrvgnd_1
XFILLER_4_15 VPWR VGND VPWR VGND sky130_ef_sc_hd__decap_12
X_727_ clknet_4_1_0_wr_clk _095_ VGND VGND VPWR VPWR mem\[2\]\[7\] sky130_fd_sc_hd__dfxtp_1
XPHY_EDGE_ROW_31_Left_82 VGND VGND VPWR VPWR sky130_fd_sc_hd__decap_3
X_658_ clknet_4_6_0_wr_clk _026_ VGND VGND VPWR VPWR mem\[12\]\[2\] sky130_fd_sc_hd__dfxtp_1
X_589_ net65 net173 _301_ VGND VGND VPWR VPWR _096_ sky130_fd_sc_hd__mux2_1
XTAP_TAPCELL_ROW_1_114 VGND VPWR sky130_fd_sc_hd__tapvpwrvgnd_1
Xfanout58 net18 VGND VGND VPWR VPWR net58 sky130_fd_sc_hd__buf_1
XTAP_TAPCELL_ROW_24_227 VGND VPWR sky130_fd_sc_hd__tapvpwrvgnd_1
Xfanout36 _226_ VGND VGND VPWR VPWR net36 sky130_fd_sc_hd__clkbuf_4
Xfanout47 net50 VGND VGND VPWR VPWR net47 sky130_fd_sc_hd__buf_4
XTAP_TAPCELL_ROW_32_271 VGND VPWR sky130_fd_sc_hd__tapvpwrvgnd_1
Xfanout69 net12 VGND VGND VPWR VPWR net69 sky130_fd_sc_hd__buf_2
XFILLER_38_21 VGND VGND VPWR VPWR sky130_fd_sc_hd__decap_6
XFILLER_9_225 VPWR VGND VPWR VGND sky130_ef_sc_hd__decap_12
X_374_ net49 _183_ VGND VGND VPWR VPWR _204_ sky130_fd_sc_hd__xor2_1
X_512_ net124 net52 _289_ VGND VGND VPWR VPWR _031_ sky130_fd_sc_hd__mux2_1
X_443_ mem\[8\]\[1\] mem\[9\]\[1\] mem\[10\]\[1\] mem\[11\]\[1\] net49 net45 VGND
+ VGND VPWR VPWR _251_ sky130_fd_sc_hd__mux4_1
XFILLER_48_195 VGND VGND VPWR VPWR sky130_fd_sc_hd__fill_1
XTAP_TAPCELL_ROW_46_341 VGND VPWR sky130_fd_sc_hd__tapvpwrvgnd_1
XFILLER_24_45 VGND VGND VPWR VPWR sky130_fd_sc_hd__decap_6
XFILLER_6_206 VPWR VGND VPWR VGND sky130_ef_sc_hd__decap_12
XFILLER_6_3 VPWR VGND VPWR VGND sky130_ef_sc_hd__decap_12
XFILLER_1_27 VPWR VGND VPWR VGND sky130_ef_sc_hd__decap_12
XTAP_TAPCELL_ROW_43_322 VGND VPWR sky130_fd_sc_hd__tapvpwrvgnd_1
X_357_ _180_ _186_ VGND VGND VPWR VPWR _187_ sky130_fd_sc_hd__or2_1
X_426_ rd_bin\[3\] _231_ VGND VGND VPWR VPWR rd_gray_next\[2\] sky130_fd_sc_hd__xnor2_1
XFILLER_5_261 VPWR VGND VPWR VGND sky130_ef_sc_hd__decap_12
XFILLER_39_3 VPWR VGND VPWR VGND sky130_ef_sc_hd__decap_12
Xinput4 aempty_threshold[3] VGND VGND VPWR VPWR net4 sky130_fd_sc_hd__clkbuf_1
XFILLER_3_209 VPWR VGND VPWR VGND sky130_ef_sc_hd__decap_12
XFILLER_35_11 VGND VGND VPWR VPWR sky130_fd_sc_hd__fill_2
XFILLER_27_165 VGND VGND VPWR VPWR sky130_fd_sc_hd__decap_3
XFILLER_35_55 VGND VGND VPWR VPWR sky130_fd_sc_hd__fill_1
XFILLER_27_198 VPWR VGND VPWR VGND sky130_ef_sc_hd__decap_12
XFILLER_2_253 VPWR VGND VPWR VGND sky130_ef_sc_hd__decap_12
XFILLER_18_165 VPWR VGND VPWR VGND sky130_ef_sc_hd__decap_12
X_409_ net48 net36 net43 VGND VGND VPWR VPWR _229_ sky130_fd_sc_hd__a21oi_1
XFILLER_24_179 VGND VGND VPWR VPWR sky130_fd_sc_hd__decap_8
XFILLER_21_57 VGND VGND VPWR VPWR sky130_fd_sc_hd__fill_1
X_760_ clknet_4_15_0_wr_clk wr_bin_next\[3\] net74 VGND VGND VPWR VPWR wr_bin\[3\]
+ sky130_fd_sc_hd__dfrtp_1
XFILLER_46_65 VPWR VGND VPWR VGND sky130_ef_sc_hd__decap_12
X_691_ clknet_4_2_0_wr_clk _059_ VGND VGND VPWR VPWR mem\[0\]\[3\] sky130_fd_sc_hd__dfxtp_1
XFILLER_15_124 VPWR VGND VPWR VGND sky130_ef_sc_hd__decap_12
XFILLER_7_301 VGND VGND VPWR VPWR sky130_fd_sc_hd__fill_1
XFILLER_7_15 VPWR VGND VPWR VGND sky130_ef_sc_hd__decap_12
XFILLER_37_271 VGND VGND VPWR VPWR sky130_fd_sc_hd__decap_8
XFILLER_29_249 VPWR VGND VPWR VGND sky130_ef_sc_hd__decap_12
X_743_ clknet_4_5_0_wr_clk _110_ VGND VGND VPWR VPWR mem\[5\]\[6\] sky130_fd_sc_hd__dfxtp_1
XTAP_TAPCELL_ROW_7_142 VGND VPWR sky130_fd_sc_hd__tapvpwrvgnd_1
X_674_ clknet_4_9_0_wr_clk _042_ VGND VGND VPWR VPWR mem\[1\]\[2\] sky130_fd_sc_hd__dfxtp_1
XFILLER_28_293 VGND VGND VPWR VPWR sky130_fd_sc_hd__fill_1
Xhold109 mem\[15\]\[5\] VGND VGND VPWR VPWR net185 sky130_fd_sc_hd__dlygate4sd3_1
XFILLER_11_193 VPWR VGND VPWR VGND sky130_ef_sc_hd__decap_12
XFILLER_21_3 VGND VGND VPWR VPWR sky130_fd_sc_hd__fill_2
XFILLER_19_271 VGND VGND VPWR VPWR sky130_fd_sc_hd__decap_8
XFILLER_19_293 VGND VGND VPWR VPWR sky130_fd_sc_hd__decap_6
XFILLER_34_241 VGND VGND VPWR VPWR sky130_fd_sc_hd__fill_2
XFILLER_43_11 VGND VGND VPWR VPWR sky130_fd_sc_hd__fill_1
X_390_ wr_bin\[4\] _215_ VGND VGND VPWR VPWR wr_gray_next\[3\] sky130_fd_sc_hd__xnor2_1
XFILLER_40_299 VGND VGND VPWR VPWR sky130_fd_sc_hd__decap_3
XTAP_TAPCELL_ROW_10_158 VGND VPWR sky130_fd_sc_hd__tapvpwrvgnd_1
XFILLER_4_27 VGND VGND VPWR VPWR sky130_fd_sc_hd__fill_1
X_726_ clknet_4_5_0_wr_clk _094_ VGND VGND VPWR VPWR mem\[2\]\[6\] sky130_fd_sc_hd__dfxtp_1
X_657_ clknet_4_14_0_wr_clk _025_ VGND VGND VPWR VPWR mem\[12\]\[1\] sky130_fd_sc_hd__dfxtp_1
X_588_ net37 net38 _211_ VGND VGND VPWR VPWR _301_ sky130_fd_sc_hd__or3b_4
XTAP_TAPCELL_ROW_1_115 VGND VPWR sky130_fd_sc_hd__tapvpwrvgnd_1
Xfanout37 wr_bin\[3\] VGND VGND VPWR VPWR net37 sky130_fd_sc_hd__clkbuf_4
XTAP_TAPCELL_ROW_24_228 VGND VPWR sky130_fd_sc_hd__tapvpwrvgnd_1
Xfanout59 net17 VGND VGND VPWR VPWR net59 sky130_fd_sc_hd__clkbuf_2
Xfanout48 net49 VGND VGND VPWR VPWR net48 sky130_fd_sc_hd__clkbuf_4
XFILLER_22_244 VGND VGND VPWR VPWR sky130_fd_sc_hd__decap_8
XFILLER_38_11 VGND VGND VPWR VPWR sky130_fd_sc_hd__fill_1
X_511_ net100 net54 _289_ VGND VGND VPWR VPWR _030_ sky130_fd_sc_hd__mux2_1
XFILLER_9_237 VPWR VGND VPWR VGND sky130_ef_sc_hd__decap_12
X_373_ _185_ _201_ net2 VGND VGND VPWR VPWR _203_ sky130_fd_sc_hd__o21a_1
X_442_ mem\[12\]\[1\] mem\[13\]\[1\] mem\[14\]\[1\] mem\[15\]\[1\] net49 net45 VGND
+ VGND VPWR VPWR _250_ sky130_fd_sc_hd__mux4_1
XFILLER_48_141 VPWR VGND VPWR VGND sky130_ef_sc_hd__decap_12
XFILLER_48_185 VGND VGND VPWR VPWR sky130_fd_sc_hd__fill_2
X_709_ clknet_4_0_0_wr_clk _077_ VGND VGND VPWR VPWR mem\[7\]\[5\] sky130_fd_sc_hd__dfxtp_1
XFILLER_6_218 VPWR VGND VPWR VGND sky130_ef_sc_hd__decap_12
XFILLER_45_166 VGND VGND VPWR VPWR sky130_fd_sc_hd__fill_2
XFILLER_45_122 VPWR VGND VPWR VGND sky130_ef_sc_hd__decap_12
XFILLER_45_100 VPWR VGND VPWR VGND sky130_ef_sc_hd__decap_12
XTAP_TAPCELL_ROW_43_323 VGND VPWR sky130_fd_sc_hd__tapvpwrvgnd_1
XFILLER_1_39 VGND VGND VPWR VPWR sky130_fd_sc_hd__decap_8
X_356_ net41 _179_ VGND VGND VPWR VPWR _186_ sky130_fd_sc_hd__and2_1
X_425_ wr_gray_sync2\[3\] rd_gray_next\[3\] VGND VGND VPWR VPWR _240_ sky130_fd_sc_hd__xnor2_1
XFILLER_5_273 VGND VGND VPWR VPWR sky130_fd_sc_hd__decap_6
Xinput5 aempty_threshold[4] VGND VGND VPWR VPWR net5 sky130_fd_sc_hd__clkbuf_1
XFILLER_19_35 VGND VGND VPWR VPWR sky130_fd_sc_hd__decap_3
XFILLER_19_46 VGND VGND VPWR VPWR sky130_fd_sc_hd__fill_1
XFILLER_19_57 VGND VGND VPWR VPWR sky130_fd_sc_hd__decap_6
XFILLER_42_169 VGND VGND VPWR VPWR sky130_fd_sc_hd__fill_1
XFILLER_2_265 VPWR VGND VPWR VGND sky130_ef_sc_hd__decap_12
XFILLER_2_221 VPWR VGND VPWR VGND sky130_ef_sc_hd__decap_12
X_408_ _227_ _228_ VGND VGND VPWR VPWR rd_bin_next\[0\] sky130_fd_sc_hd__nor2_1
XFILLER_18_177 VGND VGND VPWR VPWR sky130_fd_sc_hd__decap_4
XFILLER_33_169 VPWR VGND VPWR VGND sky130_ef_sc_hd__decap_12
X_339_ _138_ _152_ _153_ _142_ VGND VGND VPWR VPWR _170_ sky130_fd_sc_hd__a2bb2o_1
X_690_ clknet_4_9_0_wr_clk _058_ VGND VGND VPWR VPWR mem\[0\]\[2\] sky130_fd_sc_hd__dfxtp_1
XFILLER_46_77 VGND VGND VPWR VPWR sky130_fd_sc_hd__decap_6
XFILLER_15_103 VGND VGND VPWR VPWR sky130_fd_sc_hd__fill_1
XFILLER_15_136 VPWR VGND VPWR VGND sky130_ef_sc_hd__decap_12
XFILLER_15_169 VGND VGND VPWR VPWR sky130_fd_sc_hd__decap_6
Xclkbuf_4_15_0_wr_clk clknet_0_wr_clk VGND VGND VPWR VPWR clknet_4_15_0_wr_clk sky130_fd_sc_hd__clkbuf_8
XFILLER_7_27 VPWR VGND VPWR VGND sky130_ef_sc_hd__decap_12
XFILLER_38_239 VGND VGND VPWR VPWR sky130_fd_sc_hd__fill_1
XFILLER_44_209 VPWR VGND VPWR VGND sky130_ef_sc_hd__decap_12
XTAP_TAPCELL_ROW_7_143 VGND VPWR sky130_fd_sc_hd__tapvpwrvgnd_1
X_742_ clknet_4_0_0_wr_clk _109_ VGND VGND VPWR VPWR mem\[5\]\[5\] sky130_fd_sc_hd__dfxtp_1
X_673_ clknet_4_9_0_wr_clk _041_ VGND VGND VPWR VPWR mem\[1\]\[1\] sky130_fd_sc_hd__dfxtp_1
XFILLER_28_272 VGND VGND VPWR VPWR sky130_fd_sc_hd__fill_2
XFILLER_7_165 VGND VGND VPWR VPWR sky130_fd_sc_hd__decap_3
XFILLER_14_3 VPWR VGND VPWR VGND sky130_ef_sc_hd__decap_12
XFILLER_34_253 VGND VGND VPWR VPWR sky130_fd_sc_hd__decap_4
XFILLER_27_57 VPWR VGND VPWR VGND sky130_ef_sc_hd__decap_12
XTAP_TAPCELL_ROW_10_159 VGND VPWR sky130_fd_sc_hd__tapvpwrvgnd_1
X_656_ clknet_4_7_0_wr_clk _024_ VGND VGND VPWR VPWR mem\[12\]\[0\] sky130_fd_sc_hd__dfxtp_1
X_725_ clknet_4_0_0_wr_clk _093_ VGND VGND VPWR VPWR mem\[2\]\[5\] sky130_fd_sc_hd__dfxtp_1
XFILLER_16_253 VPWR VGND VPWR VGND sky130_ef_sc_hd__decap_12
X_587_ net149 net52 _300_ VGND VGND VPWR VPWR _095_ sky130_fd_sc_hd__mux2_1
XFILLER_31_223 VGND VGND VPWR VPWR sky130_fd_sc_hd__fill_1
XPHY_EDGE_ROW_18_Left_69 VGND VGND VPWR VPWR sky130_fd_sc_hd__decap_3
XTAP_TAPCELL_ROW_1_116 VGND VPWR sky130_fd_sc_hd__tapvpwrvgnd_1
Xfanout38 wr_bin\[2\] VGND VGND VPWR VPWR net38 sky130_fd_sc_hd__buf_2
XFILLER_13_15 VGND VGND VPWR VPWR sky130_fd_sc_hd__fill_2
Xfanout49 net50 VGND VGND VPWR VPWR net49 sky130_fd_sc_hd__clkbuf_4
XTAP_TAPCELL_ROW_24_229 VGND VPWR sky130_fd_sc_hd__tapvpwrvgnd_1
XFILLER_13_26 VGND VGND VPWR VPWR sky130_fd_sc_hd__decap_4
XFILLER_1_105 VGND VGND VPWR VPWR sky130_fd_sc_hd__decap_6
X_510_ net175 net56 _289_ VGND VGND VPWR VPWR _029_ sky130_fd_sc_hd__mux2_1
X_441_ _248_ _247_ net41 VGND VGND VPWR VPWR _249_ sky130_fd_sc_hd__mux2_1
XFILLER_9_249 VPWR VGND VPWR VGND sky130_ef_sc_hd__decap_12
X_372_ net2 _185_ _201_ VGND VGND VPWR VPWR _202_ sky130_fd_sc_hd__or3_1
XFILLER_13_245 VGND VGND VPWR VPWR sky130_fd_sc_hd__decap_4
XFILLER_13_256 VPWR VGND VPWR VGND sky130_ef_sc_hd__decap_12
Xclkbuf_4_3_0_wr_clk clknet_0_wr_clk VGND VGND VPWR VPWR clknet_4_3_0_wr_clk sky130_fd_sc_hd__clkbuf_8
XFILLER_48_153 VPWR VGND VPWR VGND sky130_ef_sc_hd__decap_12
XFILLER_48_197 VGND VGND VPWR VPWR sky130_fd_sc_hd__fill_2
X_708_ clknet_4_10_0_wr_clk _076_ VGND VGND VPWR VPWR mem\[7\]\[4\] sky130_fd_sc_hd__dfxtp_1
X_639_ net68 _007_ net76 VGND VGND VPWR VPWR net34 sky130_fd_sc_hd__dfrtp_1
XTAP_TAPCELL_ROW_20_210 VGND VPWR sky130_fd_sc_hd__tapvpwrvgnd_1
XFILLER_49_55 VGND VGND VPWR VPWR sky130_fd_sc_hd__fill_1
XFILLER_45_134 VGND VGND VPWR VPWR sky130_fd_sc_hd__decap_6
XTAP_TAPCELL_ROW_43_324 VGND VPWR sky130_fd_sc_hd__tapvpwrvgnd_1
X_424_ rd_bin\[4\] _239_ VGND VGND VPWR VPWR rd_gray_next\[3\] sky130_fd_sc_hd__xnor2_1
X_355_ net48 _183_ _184_ VGND VGND VPWR VPWR _185_ sky130_fd_sc_hd__a21oi_1
Xinput6 afull_threshold[0] VGND VGND VPWR VPWR net6 sky130_fd_sc_hd__clkbuf_1
XFILLER_36_145 VGND VGND VPWR VPWR sky130_fd_sc_hd__fill_1
XFILLER_35_57 VGND VGND VPWR VPWR sky130_fd_sc_hd__fill_1
XFILLER_50_181 VPWR VGND VPWR VGND sky130_ef_sc_hd__decap_12
XPHY_EDGE_ROW_14_Right_14 VGND VGND VPWR VPWR sky130_fd_sc_hd__decap_3
XFILLER_2_277 VPWR VGND VPWR VGND sky130_ef_sc_hd__decap_12
XFILLER_2_233 VPWR VGND VPWR VGND sky130_ef_sc_hd__decap_12
XPHY_EDGE_ROW_23_Right_23 VGND VGND VPWR VPWR sky130_fd_sc_hd__decap_3
X_338_ _154_ _168_ _142_ VGND VGND VPWR VPWR _169_ sky130_fd_sc_hd__a21o_1
XFILLER_41_192 VPWR VGND VPWR VGND sky130_ef_sc_hd__decap_12
X_407_ net48 net36 VGND VGND VPWR VPWR _228_ sky130_fd_sc_hd__and2_1
XFILLER_18_189 VGND VGND VPWR VPWR sky130_fd_sc_hd__decap_6
XPHY_EDGE_ROW_32_Right_32 VGND VGND VPWR VPWR sky130_fd_sc_hd__decap_3
XFILLER_33_104 VGND VGND VPWR VPWR sky130_fd_sc_hd__fill_1
XFILLER_44_3 VPWR VGND VPWR VGND sky130_ef_sc_hd__decap_12
XPHY_EDGE_ROW_41_Right_41 VGND VGND VPWR VPWR sky130_fd_sc_hd__decap_3
XPHY_EDGE_ROW_50_Right_50 VGND VGND VPWR VPWR sky130_fd_sc_hd__decap_3
XFILLER_49_281 VPWR VGND VPWR VGND sky130_ef_sc_hd__decap_12
XFILLER_2_83 VGND VGND VPWR VPWR sky130_fd_sc_hd__fill_1
XFILLER_24_137 VGND VGND VPWR VPWR sky130_fd_sc_hd__decap_3
XPHY_EDGE_ROW_6_Left_57 VGND VGND VPWR VPWR sky130_fd_sc_hd__decap_3
XFILLER_15_148 VGND VGND VPWR VPWR sky130_fd_sc_hd__decap_4
XFILLER_7_39 VPWR VGND VPWR VGND sky130_ef_sc_hd__decap_12
XFILLER_46_251 VGND VGND VPWR VPWR sky130_fd_sc_hd__fill_1
Xinput20 wr_data[6] VGND VGND VPWR VPWR net20 sky130_fd_sc_hd__buf_1
XTAP_TAPCELL_ROW_16_187 VGND VPWR sky130_fd_sc_hd__tapvpwrvgnd_1
XPHY_EDGE_ROW_48_Left_99 VGND VGND VPWR VPWR sky130_fd_sc_hd__decap_3
XFILLER_32_25 VGND VGND VPWR VPWR sky130_fd_sc_hd__decap_3
XTAP_TAPCELL_ROW_7_144 VGND VPWR sky130_fd_sc_hd__tapvpwrvgnd_1
X_672_ clknet_4_13_0_wr_clk _040_ VGND VGND VPWR VPWR mem\[1\]\[0\] sky130_fd_sc_hd__dfxtp_1
X_741_ clknet_4_11_0_wr_clk _108_ VGND VGND VPWR VPWR mem\[5\]\[4\] sky130_fd_sc_hd__dfxtp_1
XFILLER_43_265 VPWR VGND VPWR VGND sky130_ef_sc_hd__decap_12
XPHY_EDGE_ROW_4_Right_4 VGND VGND VPWR VPWR sky130_fd_sc_hd__decap_3
XFILLER_25_221 VGND VGND VPWR VPWR sky130_fd_sc_hd__decap_3
XFILLER_27_69 VGND VGND VPWR VPWR sky130_fd_sc_hd__fill_1
XFILLER_43_68 VGND VGND VPWR VPWR sky130_fd_sc_hd__fill_1
XFILLER_43_57 VGND VGND VPWR VPWR sky130_fd_sc_hd__fill_2
XFILLER_40_224 VPWR VGND VPWR VGND sky130_ef_sc_hd__decap_12
XTAP_TAPCELL_ROW_35_282 VGND VPWR sky130_fd_sc_hd__tapvpwrvgnd_1
X_724_ clknet_4_10_0_wr_clk _092_ VGND VGND VPWR VPWR mem\[2\]\[4\] sky130_fd_sc_hd__dfxtp_1
X_586_ net113 net54 _300_ VGND VGND VPWR VPWR _094_ sky130_fd_sc_hd__mux2_1
XPHY_EDGE_ROW_9_Left_60 VGND VGND VPWR VPWR sky130_fd_sc_hd__decap_3
XFILLER_16_221 VGND VGND VPWR VPWR sky130_fd_sc_hd__decap_3
XFILLER_16_265 VPWR VGND VPWR VGND sky130_ef_sc_hd__decap_12
X_655_ clknet_4_4_0_wr_clk _023_ VGND VGND VPWR VPWR mem\[13\]\[7\] sky130_fd_sc_hd__dfxtp_1
XFILLER_31_279 VGND VGND VPWR VPWR sky130_fd_sc_hd__fill_1
XTAP_TAPCELL_ROW_49_352 VGND VPWR sky130_fd_sc_hd__tapvpwrvgnd_1
XFILLER_22_268 VGND VGND VPWR VPWR sky130_fd_sc_hd__fill_2
Xfanout39 rd_bin\[3\] VGND VGND VPWR VPWR net39 sky130_fd_sc_hd__buf_4
X_371_ net49 _183_ _184_ VGND VGND VPWR VPWR _201_ sky130_fd_sc_hd__and3_1
X_440_ mem\[0\]\[1\] mem\[1\]\[1\] mem\[2\]\[1\] mem\[3\]\[1\] net48 rd_bin\[1\] VGND
+ VGND VPWR VPWR _248_ sky130_fd_sc_hd__mux4_1
XPHY_EDGE_ROW_35_Left_86 VGND VGND VPWR VPWR sky130_fd_sc_hd__decap_3
XFILLER_13_268 VPWR VGND VPWR VGND sky130_ef_sc_hd__decap_12
XFILLER_48_165 VPWR VGND VPWR VGND sky130_ef_sc_hd__decap_12
XFILLER_0_161 VGND VGND VPWR VPWR sky130_fd_sc_hd__decap_3
XFILLER_0_194 VGND VGND VPWR VPWR sky130_fd_sc_hd__fill_2
X_707_ clknet_4_3_0_wr_clk _075_ VGND VGND VPWR VPWR mem\[7\]\[3\] sky130_fd_sc_hd__dfxtp_1
X_638_ net69 _006_ net75 VGND VGND VPWR VPWR net33 sky130_fd_sc_hd__dfrtp_1
X_569_ net51 net202 _298_ VGND VGND VPWR VPWR _079_ sky130_fd_sc_hd__mux2_1
XFILLER_8_250 VGND VGND VPWR VPWR sky130_fd_sc_hd__fill_2
XFILLER_24_15 VGND VGND VPWR VPWR sky130_fd_sc_hd__decap_4
XFILLER_10_205 VPWR VGND VPWR VGND sky130_ef_sc_hd__decap_12
XFILLER_10_249 VGND VGND VPWR VPWR sky130_fd_sc_hd__decap_3
XTAP_TAPCELL_ROW_20_211 VGND VPWR sky130_fd_sc_hd__tapvpwrvgnd_1
XTAP_TAPCELL_ROW_43_325 VGND VPWR sky130_fd_sc_hd__tapvpwrvgnd_1
X_354_ net43 _181_ VGND VGND VPWR VPWR _184_ sky130_fd_sc_hd__xor2_1
X_423_ net40 _230_ net39 VGND VGND VPWR VPWR _239_ sky130_fd_sc_hd__a21oi_1
Xinput7 afull_threshold[1] VGND VGND VPWR VPWR net7 sky130_fd_sc_hd__clkbuf_1
XFILLER_35_47 VGND VGND VPWR VPWR sky130_fd_sc_hd__decap_8
XFILLER_50_193 VGND VGND VPWR VPWR sky130_fd_sc_hd__decap_3
XFILLER_4_3 VPWR VGND VPWR VGND sky130_ef_sc_hd__decap_12
XFILLER_2_289 VPWR VGND VPWR VGND sky130_ef_sc_hd__decap_12
XFILLER_2_245 VGND VGND VPWR VPWR sky130_fd_sc_hd__decap_6
X_337_ _138_ _152_ _153_ VGND VGND VPWR VPWR _168_ sky130_fd_sc_hd__nand3_1
X_406_ net48 net36 VGND VGND VPWR VPWR _227_ sky130_fd_sc_hd__nor2_1
XFILLER_49_293 VGND VGND VPWR VPWR sky130_fd_sc_hd__decap_8
XFILLER_37_3 VGND VGND VPWR VPWR sky130_fd_sc_hd__fill_2
XPHY_EDGE_ROW_22_Left_73 VGND VGND VPWR VPWR sky130_fd_sc_hd__decap_3
XFILLER_11_71 VGND VGND VPWR VPWR sky130_fd_sc_hd__decap_3
Xinput10 afull_threshold[4] VGND VGND VPWR VPWR net10 sky130_fd_sc_hd__clkbuf_1
XTAP_TAPCELL_ROW_16_188 VGND VPWR sky130_fd_sc_hd__tapvpwrvgnd_1
Xinput21 wr_data[7] VGND VGND VPWR VPWR net21 sky130_fd_sc_hd__buf_1
XFILLER_16_27 VGND VGND VPWR VPWR sky130_fd_sc_hd__fill_1
XTAP_TAPCELL_ROW_7_145 VGND VPWR sky130_fd_sc_hd__tapvpwrvgnd_1
X_740_ clknet_4_3_0_wr_clk _107_ VGND VGND VPWR VPWR mem\[5\]\[3\] sky130_fd_sc_hd__dfxtp_1
XFILLER_43_277 VGND VGND VPWR VPWR sky130_fd_sc_hd__decap_3
XFILLER_43_211 VPWR VGND VPWR VGND sky130_ef_sc_hd__decap_12
X_671_ clknet_4_1_0_wr_clk _039_ VGND VGND VPWR VPWR mem\[11\]\[7\] sky130_fd_sc_hd__dfxtp_1
XFILLER_7_101 VGND VGND VPWR VPWR sky130_fd_sc_hd__fill_2
XFILLER_19_252 VGND VGND VPWR VPWR sky130_fd_sc_hd__decap_6
XFILLER_8_94 VGND VGND VPWR VPWR sky130_fd_sc_hd__fill_1
XFILLER_8_83 VGND VGND VPWR VPWR sky130_fd_sc_hd__fill_1
XFILLER_25_233 VGND VGND VPWR VPWR sky130_fd_sc_hd__fill_2
XFILLER_25_255 VGND VGND VPWR VPWR sky130_fd_sc_hd__fill_2
XFILLER_43_25 VGND VGND VPWR VPWR sky130_fd_sc_hd__fill_2
XFILLER_40_236 VPWR VGND VPWR VGND sky130_ef_sc_hd__decap_12
XTAP_TAPCELL_ROW_35_283 VGND VPWR sky130_fd_sc_hd__tapvpwrvgnd_1
X_654_ clknet_4_5_0_wr_clk _022_ VGND VGND VPWR VPWR mem\[13\]\[6\] sky130_fd_sc_hd__dfxtp_1
X_723_ clknet_4_2_0_wr_clk _091_ VGND VGND VPWR VPWR mem\[2\]\[3\] sky130_fd_sc_hd__dfxtp_1
X_585_ net105 net56 _300_ VGND VGND VPWR VPWR _093_ sky130_fd_sc_hd__mux2_1
XFILLER_16_244 VGND VGND VPWR VPWR sky130_fd_sc_hd__decap_8
XFILLER_31_225 VPWR VGND VPWR VGND sky130_ef_sc_hd__decap_12
XTAP_TAPCELL_ROW_49_353 VGND VPWR sky130_fd_sc_hd__tapvpwrvgnd_1
XFILLER_30_291 VGND VGND VPWR VPWR sky130_fd_sc_hd__decap_8
X_370_ _188_ _198_ net3 VGND VGND VPWR VPWR _200_ sky130_fd_sc_hd__o21a_1
XFILLER_13_203 VGND VGND VPWR VPWR sky130_fd_sc_hd__decap_4
XFILLER_48_177 VGND VGND VPWR VPWR sky130_fd_sc_hd__decap_8
X_637_ net68 _005_ net76 VGND VGND VPWR VPWR net32 sky130_fd_sc_hd__dfrtp_1
X_706_ clknet_4_4_0_wr_clk _074_ VGND VGND VPWR VPWR mem\[7\]\[2\] sky130_fd_sc_hd__dfxtp_1
X_568_ net53 net207 _298_ VGND VGND VPWR VPWR _078_ sky130_fd_sc_hd__mux2_1
X_499_ net88 net57 _287_ VGND VGND VPWR VPWR _020_ sky130_fd_sc_hd__mux2_1
XFILLER_5_73 VGND VGND VPWR VPWR sky130_fd_sc_hd__fill_1
XFILLER_39_166 VGND VGND VPWR VPWR sky130_fd_sc_hd__fill_2
XFILLER_39_122 VPWR VGND VPWR VGND sky130_ef_sc_hd__decap_12
XFILLER_39_111 VGND VGND VPWR VPWR sky130_fd_sc_hd__fill_1
XFILLER_24_27 VGND VGND VPWR VPWR sky130_fd_sc_hd__fill_1
XFILLER_40_37 VPWR VGND VPWR VGND sky130_ef_sc_hd__decap_12
XFILLER_40_15 VPWR VGND VPWR VGND sky130_ef_sc_hd__decap_12
XFILLER_10_217 VPWR VGND VPWR VGND sky130_ef_sc_hd__decap_12
XFILLER_49_57 VPWR VGND VPWR VGND sky130_ef_sc_hd__decap_12
XFILLER_45_169 VPWR VGND VPWR VGND sky130_ef_sc_hd__decap_12
XTAP_TAPCELL_ROW_43_326 VGND VPWR sky130_fd_sc_hd__tapvpwrvgnd_1
X_353_ wr_gray_sync2\[0\] _181_ VGND VGND VPWR VPWR _183_ sky130_fd_sc_hd__xnor2_1
X_422_ _233_ _234_ _235_ _191_ _237_ VGND VGND VPWR VPWR _238_ sky130_fd_sc_hd__o221a_1
XFILLER_14_93 VGND VGND VPWR VPWR sky130_fd_sc_hd__fill_2
Xinput8 afull_threshold[2] VGND VGND VPWR VPWR net8 sky130_fd_sc_hd__clkbuf_1
XTAP_TAPCELL_ROW_40_307 VGND VPWR sky130_fd_sc_hd__tapvpwrvgnd_1
XFILLER_27_169 VPWR VGND VPWR VGND sky130_ef_sc_hd__decap_12
XFILLER_26_180 VGND VGND VPWR VPWR sky130_fd_sc_hd__decap_6
X_336_ _157_ _166_ _141_ VGND VGND VPWR VPWR _167_ sky130_fd_sc_hd__a21o_1
X_405_ net25 net13 VGND VGND VPWR VPWR _226_ sky130_fd_sc_hd__and2b_2
XFILLER_49_261 VPWR VGND VPWR VGND sky130_ef_sc_hd__decap_12
XFILLER_2_85 VPWR VGND VPWR VGND sky130_ef_sc_hd__decap_12
XFILLER_32_194 VGND VGND VPWR VPWR sky130_fd_sc_hd__fill_2
XFILLER_11_61 VGND VGND VPWR VPWR sky130_fd_sc_hd__fill_1
XTAP_TAPCELL_ROW_16_189 VGND VPWR sky130_fd_sc_hd__tapvpwrvgnd_1
Xinput22 wr_en VGND VGND VPWR VPWR net22 sky130_fd_sc_hd__clkbuf_1
X_319_ full_compare\[1\] _148_ VGND VGND VPWR VPWR _150_ sky130_fd_sc_hd__xnor2_2
Xinput11 arst_n VGND VGND VPWR VPWR net11 sky130_fd_sc_hd__clkbuf_1
XFILLER_37_220 VGND VGND VPWR VPWR sky130_fd_sc_hd__decap_4
X_670_ clknet_4_5_0_wr_clk _038_ VGND VGND VPWR VPWR mem\[11\]\[6\] sky130_fd_sc_hd__dfxtp_1
XTAP_TAPCELL_ROW_7_146 VGND VPWR sky130_fd_sc_hd__tapvpwrvgnd_1
XFILLER_43_223 VGND VGND VPWR VPWR sky130_fd_sc_hd__fill_1
XFILLER_28_253 VGND VGND VPWR VPWR sky130_fd_sc_hd__decap_4
XFILLER_28_264 VGND VGND VPWR VPWR sky130_fd_sc_hd__fill_1
XFILLER_7_113 VGND VGND VPWR VPWR sky130_fd_sc_hd__decap_4
X_799_ clknet_4_0_0_wr_clk _125_ VGND VGND VPWR VPWR mem\[15\]\[5\] sky130_fd_sc_hd__dfxtp_1
XTAP_TAPCELL_ROW_12_170 VGND VPWR sky130_fd_sc_hd__tapvpwrvgnd_1
XTAP_TAPCELL_ROW_4_127 VGND VPWR sky130_fd_sc_hd__tapvpwrvgnd_1
XFILLER_25_278 VGND VGND VPWR VPWR sky130_fd_sc_hd__fill_2
XFILLER_40_259 VGND VGND VPWR VPWR sky130_fd_sc_hd__fill_1
XFILLER_40_248 VGND VGND VPWR VPWR sky130_fd_sc_hd__decap_4
XTAP_TAPCELL_ROW_35_284 VGND VPWR sky130_fd_sc_hd__tapvpwrvgnd_1
XFILLER_4_138 VGND VGND VPWR VPWR sky130_fd_sc_hd__fill_2
X_653_ clknet_4_2_0_wr_clk _021_ VGND VGND VPWR VPWR mem\[13\]\[5\] sky130_fd_sc_hd__dfxtp_1
X_722_ clknet_4_6_0_wr_clk _090_ VGND VGND VPWR VPWR mem\[2\]\[2\] sky130_fd_sc_hd__dfxtp_1
X_584_ net181 net57 _300_ VGND VGND VPWR VPWR _092_ sky130_fd_sc_hd__mux2_1
XTAP_TAPCELL_ROW_26_240 VGND VPWR sky130_fd_sc_hd__tapvpwrvgnd_1
XFILLER_31_237 VGND VGND VPWR VPWR sky130_fd_sc_hd__decap_4
XFILLER_12_3 VGND VGND VPWR VPWR sky130_fd_sc_hd__decap_6
XTAP_TAPCELL_ROW_49_354 VGND VPWR sky130_fd_sc_hd__tapvpwrvgnd_1
XFILLER_21_270 VGND VGND VPWR VPWR sky130_fd_sc_hd__fill_2
XFILLER_48_123 VPWR VGND VPWR VGND sky130_ef_sc_hd__decap_12
XFILLER_0_141 VPWR VGND VPWR VGND sky130_ef_sc_hd__decap_12
XFILLER_0_174 VPWR VGND VPWR VGND sky130_ef_sc_hd__decap_12
X_567_ net55 net194 _298_ VGND VGND VPWR VPWR _077_ sky130_fd_sc_hd__mux2_1
X_636_ net67 _004_ net71 VGND VGND VPWR VPWR net31 sky130_fd_sc_hd__dfrtp_1
X_705_ clknet_4_8_0_wr_clk _073_ VGND VGND VPWR VPWR mem\[7\]\[1\] sky130_fd_sc_hd__dfxtp_1
XFILLER_44_80 VGND VGND VPWR VPWR sky130_fd_sc_hd__decap_4
XFILLER_8_230 VPWR VGND VPWR VGND sky130_ef_sc_hd__decap_12
X_498_ net85 net59 _287_ VGND VGND VPWR VPWR _019_ sky130_fd_sc_hd__mux2_1
XFILLER_39_134 VPWR VGND VPWR VGND sky130_ef_sc_hd__decap_12
XFILLER_39_101 VGND VGND VPWR VPWR sky130_fd_sc_hd__fill_2
XFILLER_40_49 VGND VGND VPWR VPWR sky130_fd_sc_hd__decap_3
XFILLER_40_27 VGND VGND VPWR VPWR sky130_fd_sc_hd__fill_1
XFILLER_10_229 VPWR VGND VPWR VGND sky130_ef_sc_hd__decap_12
XFILLER_49_69 VPWR VGND VPWR VGND sky130_ef_sc_hd__decap_12
X_421_ _191_ _235_ _236_ VGND VGND VPWR VPWR _237_ sky130_fd_sc_hd__a21oi_1
X_352_ net43 _181_ VGND VGND VPWR VPWR _182_ sky130_fd_sc_hd__and2b_1
XFILLER_14_83 VGND VGND VPWR VPWR sky130_fd_sc_hd__fill_1
XFILLER_5_211 VPWR VGND VPWR VGND sky130_ef_sc_hd__decap_12
Xinput9 afull_threshold[3] VGND VGND VPWR VPWR net9 sky130_fd_sc_hd__clkbuf_1
X_619_ net58 net177 net35 VGND VGND VPWR VPWR _124_ sky130_fd_sc_hd__mux2_1
XFILLER_42_129 VGND VGND VPWR VPWR sky130_fd_sc_hd__fill_2
XTAP_TAPCELL_ROW_40_308 VGND VPWR sky130_fd_sc_hd__tapvpwrvgnd_1
X_404_ _216_ _225_ VGND VGND VPWR VPWR full_next sky130_fd_sc_hd__nor2_1
XFILLER_18_137 VGND VGND VPWR VPWR sky130_fd_sc_hd__decap_3
XFILLER_33_129 VGND VGND VPWR VPWR sky130_fd_sc_hd__fill_2
X_335_ _151_ _154_ _156_ VGND VGND VPWR VPWR _166_ sky130_fd_sc_hd__nand3_1
XFILLER_41_92 VGND VGND VPWR VPWR sky130_fd_sc_hd__decap_4
XFILLER_49_273 VGND VGND VPWR VPWR sky130_fd_sc_hd__decap_6
XFILLER_2_97 VGND VGND VPWR VPWR sky130_fd_sc_hd__decap_6
XPHY_EDGE_ROW_10_Right_10 VGND VGND VPWR VPWR sky130_fd_sc_hd__decap_3
XFILLER_24_129 VGND VGND VPWR VPWR sky130_fd_sc_hd__decap_8
XFILLER_46_15 VPWR VGND VPWR VGND sky130_ef_sc_hd__decap_12
XFILLER_46_221 VGND VGND VPWR VPWR sky130_fd_sc_hd__fill_1
X_318_ net38 _148_ VGND VGND VPWR VPWR _149_ sky130_fd_sc_hd__nand2_1
Xinput12 rd_clk VGND VGND VPWR VPWR net12 sky130_fd_sc_hd__clkbuf_1
XFILLER_42_3 VGND VGND VPWR VPWR sky130_fd_sc_hd__fill_2
XFILLER_43_246 VGND VGND VPWR VPWR sky130_fd_sc_hd__decap_8
Xclkbuf_4_6_0_wr_clk clknet_0_wr_clk VGND VGND VPWR VPWR clknet_4_6_0_wr_clk sky130_fd_sc_hd__clkbuf_8
XFILLER_7_169 VGND VGND VPWR VPWR sky130_fd_sc_hd__decap_8
XFILLER_22_50 VGND VGND VPWR VPWR sky130_fd_sc_hd__decap_8
XFILLER_22_83 VGND VGND VPWR VPWR sky130_fd_sc_hd__fill_1
X_798_ clknet_4_11_0_wr_clk _124_ VGND VGND VPWR VPWR mem\[15\]\[4\] sky130_fd_sc_hd__dfxtp_1
XFILLER_8_41 VGND VGND VPWR VPWR sky130_fd_sc_hd__decap_8
XTAP_TAPCELL_ROW_12_171 VGND VPWR sky130_fd_sc_hd__tapvpwrvgnd_1
XTAP_TAPCELL_ROW_4_128 VGND VPWR sky130_fd_sc_hd__tapvpwrvgnd_1
XTAP_TAPCELL_ROW_35_285 VGND VPWR sky130_fd_sc_hd__tapvpwrvgnd_1
XFILLER_0_301 VGND VGND VPWR VPWR sky130_fd_sc_hd__fill_1
X_583_ net164 net59 _300_ VGND VGND VPWR VPWR _091_ sky130_fd_sc_hd__mux2_1
XFILLER_16_213 VGND VGND VPWR VPWR sky130_fd_sc_hd__decap_8
X_652_ clknet_4_11_0_wr_clk _020_ VGND VGND VPWR VPWR mem\[13\]\[4\] sky130_fd_sc_hd__dfxtp_1
X_721_ clknet_4_8_0_wr_clk _089_ VGND VGND VPWR VPWR mem\[2\]\[1\] sky130_fd_sc_hd__dfxtp_1
XTAP_TAPCELL_ROW_26_241 VGND VPWR sky130_fd_sc_hd__tapvpwrvgnd_1
XFILLER_33_93 VGND VGND VPWR VPWR sky130_fd_sc_hd__decap_3
XFILLER_3_150 VGND VGND VPWR VPWR sky130_fd_sc_hd__fill_2
XTAP_TAPCELL_ROW_49_355 VGND VPWR sky130_fd_sc_hd__tapvpwrvgnd_1
Xhold1 rd_gray_sync1\[0\] VGND VGND VPWR VPWR net77 sky130_fd_sc_hd__dlygate4sd3_1
XPHY_EDGE_ROW_8_Right_8 VGND VGND VPWR VPWR sky130_fd_sc_hd__decap_3
XPHY_EDGE_ROW_39_Right_39 VGND VGND VPWR VPWR sky130_fd_sc_hd__decap_3
XFILLER_38_27 VGND VGND VPWR VPWR sky130_fd_sc_hd__fill_1
XPHY_EDGE_ROW_48_Right_48 VGND VGND VPWR VPWR sky130_fd_sc_hd__decap_3
XTAP_TAPCELL_ROW_23_222 VGND VPWR sky130_fd_sc_hd__tapvpwrvgnd_1
XFILLER_48_135 VGND VGND VPWR VPWR sky130_fd_sc_hd__decap_4
X_704_ clknet_4_6_0_wr_clk _072_ VGND VGND VPWR VPWR mem\[7\]\[0\] sky130_fd_sc_hd__dfxtp_1
XFILLER_0_153 VGND VGND VPWR VPWR sky130_fd_sc_hd__decap_8
XFILLER_0_186 VGND VGND VPWR VPWR sky130_fd_sc_hd__decap_8
XFILLER_0_197 VPWR VGND VPWR VGND sky130_ef_sc_hd__decap_12
X_635_ net68 _003_ net76 VGND VGND VPWR VPWR net30 sky130_fd_sc_hd__dfrtp_1
X_566_ net58 net205 _298_ VGND VGND VPWR VPWR _076_ sky130_fd_sc_hd__mux2_1
XFILLER_8_253 VPWR VGND VPWR VGND sky130_ef_sc_hd__decap_12
XFILLER_8_242 VGND VGND VPWR VPWR sky130_fd_sc_hd__decap_8
XFILLER_12_293 VGND VGND VPWR VPWR sky130_fd_sc_hd__decap_6
X_497_ net103 net61 _287_ VGND VGND VPWR VPWR _018_ sky130_fd_sc_hd__mux2_1
XFILLER_39_146 VPWR VGND VPWR VGND sky130_ef_sc_hd__decap_12
XFILLER_39_113 VGND VGND VPWR VPWR sky130_fd_sc_hd__fill_1
XFILLER_24_29 VGND VGND VPWR VPWR sky130_fd_sc_hd__decap_8
XFILLER_49_15 VPWR VGND VPWR VGND sky130_ef_sc_hd__decap_12
X_351_ wr_gray_sync2\[1\] _179_ VGND VGND VPWR VPWR _181_ sky130_fd_sc_hd__xnor2_2
X_420_ wr_gray_sync2\[0\] rd_gray_next\[0\] VGND VGND VPWR VPWR _236_ sky130_fd_sc_hd__xor2_1
XFILLER_5_223 VGND VGND VPWR VPWR sky130_fd_sc_hd__fill_1
XFILLER_44_171 VPWR VGND VPWR VGND sky130_ef_sc_hd__decap_12
X_549_ net96 net54 _295_ VGND VGND VPWR VPWR _062_ sky130_fd_sc_hd__mux2_1
X_618_ net60 net151 net35 VGND VGND VPWR VPWR _123_ sky130_fd_sc_hd__mux2_1
XFILLER_32_300 VGND VGND VPWR VPWR sky130_fd_sc_hd__fill_2
XFILLER_50_141 VGND VGND VPWR VPWR sky130_fd_sc_hd__fill_2
XTAP_TAPCELL_ROW_40_309 VGND VPWR sky130_fd_sc_hd__tapvpwrvgnd_1
X_334_ _159_ _164_ _140_ VGND VGND VPWR VPWR _165_ sky130_fd_sc_hd__a21o_1
X_403_ _217_ _218_ _224_ _219_ VGND VGND VPWR VPWR _225_ sky130_fd_sc_hd__or4b_1
XFILLER_1_281 VPWR VGND VPWR VGND sky130_ef_sc_hd__decap_12
XFILLER_2_65 VPWR VGND VPWR VGND sky130_ef_sc_hd__decap_12
XFILLER_17_182 VGND VGND VPWR VPWR sky130_fd_sc_hd__fill_2
XFILLER_24_119 VGND VGND VPWR VPWR sky130_fd_sc_hd__fill_2
XFILLER_32_141 VPWR VGND VPWR VGND sky130_ef_sc_hd__decap_12
XFILLER_46_27 VGND VGND VPWR VPWR sky130_fd_sc_hd__fill_1
XFILLER_2_3 VPWR VGND VPWR VGND sky130_ef_sc_hd__decap_12
X_317_ full_compare\[2\] _145_ VGND VGND VPWR VPWR _148_ sky130_fd_sc_hd__xor2_2
XFILLER_14_141 VGND VGND VPWR VPWR sky130_fd_sc_hd__decap_3
XPHY_EDGE_ROW_26_Left_77 VGND VGND VPWR VPWR sky130_fd_sc_hd__decap_3
Xinput13 rd_en VGND VGND VPWR VPWR net13 sky130_fd_sc_hd__clkbuf_1
XFILLER_35_3 VGND VGND VPWR VPWR sky130_fd_sc_hd__decap_8
XFILLER_7_126 VGND VGND VPWR VPWR sky130_fd_sc_hd__fill_1
XFILLER_47_81 VPWR VGND VPWR VGND sky130_ef_sc_hd__decap_12
X_797_ clknet_4_3_0_wr_clk _123_ VGND VGND VPWR VPWR mem\[15\]\[3\] sky130_fd_sc_hd__dfxtp_1
XTAP_TAPCELL_ROW_4_129 VGND VPWR sky130_fd_sc_hd__tapvpwrvgnd_1
XFILLER_27_29 VGND VGND VPWR VPWR sky130_fd_sc_hd__fill_1
XTAP_TAPCELL_ROW_35_286 VGND VPWR sky130_fd_sc_hd__tapvpwrvgnd_1
XFILLER_25_225 VGND VGND VPWR VPWR sky130_fd_sc_hd__decap_8
XFILLER_25_247 VGND VGND VPWR VPWR sky130_fd_sc_hd__decap_8
X_720_ clknet_4_6_0_wr_clk _088_ VGND VGND VPWR VPWR mem\[2\]\[0\] sky130_fd_sc_hd__dfxtp_1
X_651_ clknet_4_3_0_wr_clk _019_ VGND VGND VPWR VPWR mem\[13\]\[3\] sky130_fd_sc_hd__dfxtp_1
X_582_ net93 net62 _300_ VGND VGND VPWR VPWR _090_ sky130_fd_sc_hd__mux2_1
XTAP_TAPCELL_ROW_49_356 VGND VPWR sky130_fd_sc_hd__tapvpwrvgnd_1
Xhold2 rd_gray_sync1\[3\] VGND VGND VPWR VPWR net78 sky130_fd_sc_hd__dlygate4sd3_1
XFILLER_22_217 VGND VGND VPWR VPWR sky130_fd_sc_hd__decap_3
XPHY_EDGE_ROW_29_Left_80 VGND VGND VPWR VPWR sky130_fd_sc_hd__decap_3
XTAP_TAPCELL_ROW_32_267 VGND VPWR sky130_fd_sc_hd__tapvpwrvgnd_1
XPHY_EDGE_ROW_13_Left_64 VGND VGND VPWR VPWR sky130_fd_sc_hd__decap_3
XTAP_TAPCELL_ROW_0_110 VGND VPWR sky130_fd_sc_hd__tapvpwrvgnd_1
XFILLER_21_261 VGND VGND VPWR VPWR sky130_fd_sc_hd__fill_2
XFILLER_21_294 VGND VGND VPWR VPWR sky130_fd_sc_hd__decap_4
XTAP_TAPCELL_ROW_23_223 VGND VPWR sky130_fd_sc_hd__tapvpwrvgnd_1
XFILLER_0_121 VGND VGND VPWR VPWR sky130_fd_sc_hd__fill_1
X_703_ clknet_4_1_0_wr_clk _071_ VGND VGND VPWR VPWR mem\[8\]\[7\] sky130_fd_sc_hd__dfxtp_1
XFILLER_28_83 VGND VGND VPWR VPWR sky130_fd_sc_hd__fill_1
X_634_ net69 _002_ net75 VGND VGND VPWR VPWR net29 sky130_fd_sc_hd__dfrtp_1
XTAP_TAPCELL_ROW_46_337 VGND VPWR sky130_fd_sc_hd__tapvpwrvgnd_1
X_565_ net60 net158 _298_ VGND VGND VPWR VPWR _075_ sky130_fd_sc_hd__mux2_1
X_496_ net183 net63 _287_ VGND VGND VPWR VPWR _017_ sky130_fd_sc_hd__mux2_1
XFILLER_8_265 VPWR VGND VPWR VGND sky130_ef_sc_hd__decap_12
XFILLER_12_250 VGND VGND VPWR VPWR sky130_fd_sc_hd__fill_2
XFILLER_5_65 VGND VGND VPWR VPWR sky130_fd_sc_hd__decap_8
XFILLER_5_54 VGND VGND VPWR VPWR sky130_fd_sc_hd__fill_2
XFILLER_39_169 VPWR VGND VPWR VGND sky130_ef_sc_hd__decap_12
XFILLER_39_158 VGND VGND VPWR VPWR sky130_fd_sc_hd__decap_8
XFILLER_50_301 VGND VGND VPWR VPWR sky130_fd_sc_hd__fill_1
XFILLER_49_27 VPWR VGND VPWR VGND sky130_ef_sc_hd__decap_12
XFILLER_41_301 VGND VGND VPWR VPWR sky130_fd_sc_hd__fill_1
X_350_ net41 _179_ VGND VGND VPWR VPWR _180_ sky130_fd_sc_hd__nor2_1
XFILLER_14_85 VGND VGND VPWR VPWR sky130_fd_sc_hd__decap_8
XFILLER_5_279 VGND VGND VPWR VPWR sky130_fd_sc_hd__fill_1
XFILLER_39_93 VGND VGND VPWR VPWR sky130_fd_sc_hd__decap_8
X_617_ net62 net197 net35 VGND VGND VPWR VPWR _122_ sky130_fd_sc_hd__mux2_1
XFILLER_44_183 VPWR VGND VPWR VGND sky130_ef_sc_hd__decap_12
X_548_ net122 net56 _295_ VGND VGND VPWR VPWR _061_ sky130_fd_sc_hd__mux2_1
X_479_ mem\[12\]\[7\] mem\[13\]\[7\] mem\[14\]\[7\] mem\[15\]\[7\] net47 net44 VGND
+ VGND VPWR VPWR _281_ sky130_fd_sc_hd__mux4_1
XFILLER_23_301 VGND VGND VPWR VPWR sky130_fd_sc_hd__fill_1
XFILLER_50_197 VPWR VGND VPWR VGND sky130_ef_sc_hd__decap_12
XFILLER_50_153 VPWR VGND VPWR VGND sky130_ef_sc_hd__decap_12
X_333_ _146_ _158_ _157_ _149_ VGND VGND VPWR VPWR _164_ sky130_fd_sc_hd__o211ai_1
X_402_ _220_ _223_ VGND VGND VPWR VPWR _224_ sky130_fd_sc_hd__nand2_1
XFILLER_2_77 VGND VGND VPWR VPWR sky130_fd_sc_hd__decap_6
XFILLER_1_293 VGND VGND VPWR VPWR sky130_fd_sc_hd__decap_8
XFILLER_17_150 VPWR VGND VPWR VGND sky130_ef_sc_hd__decap_12
XFILLER_24_109 VGND VGND VPWR VPWR sky130_fd_sc_hd__fill_1
XFILLER_32_153 VPWR VGND VPWR VGND sky130_ef_sc_hd__decap_12
XFILLER_23_153 VGND VGND VPWR VPWR sky130_fd_sc_hd__fill_1
XFILLER_46_267 VPWR VGND VPWR VGND sky130_ef_sc_hd__decap_12
XFILLER_36_94 VGND VGND VPWR VPWR sky130_fd_sc_hd__fill_1
XPHY_EDGE_ROW_1_Left_52 VGND VGND VPWR VPWR sky130_fd_sc_hd__decap_3
Xinput14 wr_data[0] VGND VGND VPWR VPWR net14 sky130_fd_sc_hd__buf_1
X_316_ wr_bin\[3\] _145_ VGND VGND VPWR VPWR _147_ sky130_fd_sc_hd__nand2_1
XFILLER_28_3 VGND VGND VPWR VPWR sky130_fd_sc_hd__fill_2
XFILLER_20_167 VGND VGND VPWR VPWR sky130_fd_sc_hd__decap_3
XFILLER_20_178 VPWR VGND VPWR VGND sky130_ef_sc_hd__decap_12
XPHY_EDGE_ROW_43_Left_94 VGND VGND VPWR VPWR sky130_fd_sc_hd__decap_3
XFILLER_22_85 VPWR VGND VPWR VGND sky130_ef_sc_hd__decap_12
XFILLER_19_223 VGND VGND VPWR VPWR sky130_fd_sc_hd__fill_1
X_796_ clknet_4_4_0_wr_clk _122_ VGND VGND VPWR VPWR mem\[15\]\[2\] sky130_fd_sc_hd__dfxtp_1
XFILLER_47_93 VPWR VGND VPWR VGND sky130_ef_sc_hd__decap_12
XFILLER_33_281 VPWR VGND VPWR VGND sky130_ef_sc_hd__decap_12
XFILLER_4_119 VGND VGND VPWR VPWR sky130_fd_sc_hd__fill_2
X_650_ clknet_4_4_0_wr_clk _018_ VGND VGND VPWR VPWR mem\[13\]\[2\] sky130_fd_sc_hd__dfxtp_1
X_581_ net82 net64 _300_ VGND VGND VPWR VPWR _089_ sky130_fd_sc_hd__mux2_1
XFILLER_24_270 VPWR VGND VPWR VGND sky130_ef_sc_hd__decap_12
Xhold3 rd_gray_sync1\[2\] VGND VGND VPWR VPWR net79 sky130_fd_sc_hd__dlygate4sd3_1
X_779_ net68 wr_gray_sync1\[0\] net70 VGND VGND VPWR VPWR wr_gray_sync2\[0\] sky130_fd_sc_hd__dfrtp_1
XTAP_TAPCELL_ROW_32_268 VGND VPWR sky130_fd_sc_hd__tapvpwrvgnd_1
XTAP_TAPCELL_ROW_0_111 VGND VPWR sky130_fd_sc_hd__tapvpwrvgnd_1
XTAP_TAPCELL_ROW_23_224 VGND VPWR sky130_fd_sc_hd__tapvpwrvgnd_1
XTAP_TAPCELL_ROW_46_338 VGND VPWR sky130_fd_sc_hd__tapvpwrvgnd_1
X_702_ clknet_4_5_0_wr_clk _070_ VGND VGND VPWR VPWR mem\[8\]\[6\] sky130_fd_sc_hd__dfxtp_1
X_633_ net67 _001_ net70 VGND VGND VPWR VPWR net28 sky130_fd_sc_hd__dfrtp_1
X_495_ net156 net65 _287_ VGND VGND VPWR VPWR _016_ sky130_fd_sc_hd__mux2_1
X_564_ net61 net189 _298_ VGND VGND VPWR VPWR _074_ sky130_fd_sc_hd__mux2_1
XFILLER_8_277 VPWR VGND VPWR VGND sky130_ef_sc_hd__decap_12
XPHY_EDGE_ROW_30_Left_81 VGND VGND VPWR VPWR sky130_fd_sc_hd__decap_3
XFILLER_10_3 VPWR VGND VPWR VGND sky130_ef_sc_hd__decap_12
XFILLER_49_39 VPWR VGND VPWR VGND sky130_ef_sc_hd__decap_12
XFILLER_5_225 VPWR VGND VPWR VGND sky130_ef_sc_hd__decap_12
XFILLER_30_85 VGND VGND VPWR VPWR sky130_fd_sc_hd__decap_4
X_547_ net134 net57 _295_ VGND VGND VPWR VPWR _060_ sky130_fd_sc_hd__mux2_1
X_616_ net64 net176 net35 VGND VGND VPWR VPWR _121_ sky130_fd_sc_hd__mux2_1
XFILLER_44_195 VGND VGND VPWR VPWR sky130_fd_sc_hd__fill_1
X_478_ mem\[0\]\[7\] mem\[1\]\[7\] mem\[2\]\[7\] mem\[3\]\[7\] net46 net42 VGND VGND
+ VPWR VPWR _280_ sky130_fd_sc_hd__mux4_1
XFILLER_27_129 VGND VGND VPWR VPWR sky130_fd_sc_hd__decap_4
XFILLER_50_165 VGND VGND VPWR VPWR sky130_fd_sc_hd__decap_3
X_401_ _160_ net35 VGND VGND VPWR VPWR _223_ sky130_fd_sc_hd__xnor2_1
X_332_ _161_ _162_ _139_ VGND VGND VPWR VPWR _163_ sky130_fd_sc_hd__a21o_1
XFILLER_41_165 VGND VGND VPWR VPWR sky130_fd_sc_hd__decap_3
XFILLER_41_73 VGND VGND VPWR VPWR sky130_fd_sc_hd__fill_2
XFILLER_1_261 VPWR VGND VPWR VGND sky130_ef_sc_hd__decap_12
XFILLER_17_162 VGND VGND VPWR VPWR sky130_fd_sc_hd__decap_6
XFILLER_32_165 VPWR VGND VPWR VGND sky130_ef_sc_hd__decap_12
XFILLER_46_29 VPWR VGND VPWR VGND sky130_ef_sc_hd__decap_12
XFILLER_23_121 VPWR VGND VPWR VGND sky130_ef_sc_hd__decap_12
XFILLER_23_165 VGND VGND VPWR VPWR sky130_fd_sc_hd__decap_3
XFILLER_46_213 VGND VGND VPWR VPWR sky130_fd_sc_hd__fill_1
XFILLER_46_279 VPWR VGND VPWR VGND sky130_ef_sc_hd__decap_12
XFILLER_14_121 VGND VGND VPWR VPWR sky130_fd_sc_hd__fill_1
X_315_ wr_bin\[3\] _145_ VGND VGND VPWR VPWR _146_ sky130_fd_sc_hd__and2_1
Xinput15 wr_data[1] VGND VGND VPWR VPWR net15 sky130_fd_sc_hd__buf_1
XFILLER_37_279 VGND VGND VPWR VPWR sky130_fd_sc_hd__fill_1
Xclkbuf_4_11_0_wr_clk clknet_0_wr_clk VGND VGND VPWR VPWR clknet_4_11_0_wr_clk sky130_fd_sc_hd__clkbuf_8
XTAP_TAPCELL_ROW_15_182 VGND VPWR sky130_fd_sc_hd__tapvpwrvgnd_1
Xclkbuf_0_wr_clk wr_clk VGND VGND VPWR VPWR clknet_0_wr_clk sky130_fd_sc_hd__clkbuf_16
XFILLER_3_301 VGND VGND VPWR VPWR sky130_fd_sc_hd__fill_1
XFILLER_22_97 VPWR VGND VPWR VGND sky130_ef_sc_hd__decap_12
XFILLER_19_279 VGND VGND VPWR VPWR sky130_fd_sc_hd__fill_1
XTAP_TAPCELL_ROW_29_252 VGND VPWR sky130_fd_sc_hd__tapvpwrvgnd_1
X_795_ clknet_4_12_0_wr_clk _121_ VGND VGND VPWR VPWR mem\[15\]\[1\] sky130_fd_sc_hd__dfxtp_1
XFILLER_8_77 VGND VGND VPWR VPWR sky130_fd_sc_hd__decap_6
XFILLER_40_3 VPWR VGND VPWR VGND sky130_ef_sc_hd__decap_12
XFILLER_33_271 VGND VGND VPWR VPWR sky130_fd_sc_hd__decap_3
XFILLER_33_293 VGND VGND VPWR VPWR sky130_fd_sc_hd__fill_2
X_580_ net106 net65 _300_ VGND VGND VPWR VPWR _088_ sky130_fd_sc_hd__mux2_1
XFILLER_24_282 VGND VGND VPWR VPWR sky130_fd_sc_hd__decap_8
XFILLER_31_219 VGND VGND VPWR VPWR sky130_fd_sc_hd__decap_4
XFILLER_33_85 VGND VGND VPWR VPWR sky130_fd_sc_hd__decap_8
Xhold4 rd_gray_sync1\[1\] VGND VGND VPWR VPWR net80 sky130_fd_sc_hd__dlygate4sd3_1
X_778_ net69 wr_bin\[4\] net72 VGND VGND VPWR VPWR wr_gray_sync1\[4\] sky130_fd_sc_hd__dfrtp_1
XTAP_TAPCELL_ROW_32_269 VGND VPWR sky130_fd_sc_hd__tapvpwrvgnd_1
XTAP_TAPCELL_ROW_23_225 VGND VPWR sky130_fd_sc_hd__tapvpwrvgnd_1
XPHY_EDGE_ROW_17_Right_17 VGND VGND VPWR VPWR sky130_fd_sc_hd__decap_3
XPHY_EDGE_ROW_26_Right_26 VGND VGND VPWR VPWR sky130_fd_sc_hd__decap_3
X_632_ net69 _000_ net75 VGND VGND VPWR VPWR net27 sky130_fd_sc_hd__dfrtp_1
XTAP_TAPCELL_ROW_46_339 VGND VPWR sky130_fd_sc_hd__tapvpwrvgnd_1
X_701_ clknet_4_0_0_wr_clk _069_ VGND VGND VPWR VPWR mem\[8\]\[5\] sky130_fd_sc_hd__dfxtp_1
X_563_ net63 net142 _298_ VGND VGND VPWR VPWR _073_ sky130_fd_sc_hd__mux2_1
XFILLER_28_85 VPWR VGND VPWR VGND sky130_ef_sc_hd__decap_12
X_494_ _221_ _286_ VGND VGND VPWR VPWR _287_ sky130_fd_sc_hd__nor2_4
XPHY_EDGE_ROW_35_Right_35 VGND VGND VPWR VPWR sky130_fd_sc_hd__decap_3
XFILLER_12_230 VPWR VGND VPWR VGND sky130_ef_sc_hd__decap_12
XFILLER_8_289 VPWR VGND VPWR VGND sky130_ef_sc_hd__decap_12
XFILLER_5_23 VGND VGND VPWR VPWR sky130_fd_sc_hd__fill_2
XPHY_EDGE_ROW_44_Right_44 VGND VGND VPWR VPWR sky130_fd_sc_hd__decap_3
XFILLER_5_237 VPWR VGND VPWR VGND sky130_ef_sc_hd__decap_12
XFILLER_44_141 VGND VGND VPWR VPWR sky130_fd_sc_hd__decap_3
XTAP_TAPCELL_ROW_42_320 VGND VPWR sky130_fd_sc_hd__tapvpwrvgnd_1
X_615_ net66 net198 net35 VGND VGND VPWR VPWR _120_ sky130_fd_sc_hd__mux2_1
X_546_ net99 net59 _295_ VGND VGND VPWR VPWR _059_ sky130_fd_sc_hd__mux2_1
X_477_ mem\[4\]\[7\] mem\[5\]\[7\] mem\[6\]\[7\] mem\[7\]\[7\] net46 net43 VGND VGND
+ VPWR VPWR _279_ sky130_fd_sc_hd__mux4_1
XFILLER_50_133 VGND VGND VPWR VPWR sky130_fd_sc_hd__decap_6
X_331_ _147_ _159_ _160_ VGND VGND VPWR VPWR _162_ sky130_fd_sc_hd__a21o_1
X_400_ net37 _214_ VGND VGND VPWR VPWR _222_ sky130_fd_sc_hd__nand2_1
XFILLER_26_141 VGND VGND VPWR VPWR sky130_fd_sc_hd__decap_6
XFILLER_41_30 VGND VGND VPWR VPWR sky130_fd_sc_hd__decap_4
Xclkbuf_4_9_0_wr_clk clknet_0_wr_clk VGND VGND VPWR VPWR clknet_4_9_0_wr_clk sky130_fd_sc_hd__clkbuf_8
XFILLER_1_273 VGND VGND VPWR VPWR sky130_fd_sc_hd__decap_6
X_529_ net193 net57 _293_ VGND VGND VPWR VPWR _044_ sky130_fd_sc_hd__mux2_1
XFILLER_32_122 VPWR VGND VPWR VGND sky130_ef_sc_hd__decap_12
XFILLER_23_133 VGND VGND VPWR VPWR sky130_fd_sc_hd__decap_4
XFILLER_11_22 VGND VGND VPWR VPWR sky130_fd_sc_hd__decap_4
XFILLER_46_247 VGND VGND VPWR VPWR sky130_fd_sc_hd__decap_4
X_314_ rd_bin_sync\[4\] rd_gray_sync2\[3\] VGND VGND VPWR VPWR _145_ sky130_fd_sc_hd__xnor2_2
Xinput16 wr_data[2] VGND VGND VPWR VPWR net16 sky130_fd_sc_hd__buf_1
XFILLER_37_225 VPWR VGND VPWR VGND sky130_ef_sc_hd__decap_12
XTAP_TAPCELL_ROW_15_183 VGND VPWR sky130_fd_sc_hd__tapvpwrvgnd_1
XTAP_TAPCELL_ROW_38_297 VGND VPWR sky130_fd_sc_hd__tapvpwrvgnd_1
XFILLER_22_21 VGND VGND VPWR VPWR sky130_fd_sc_hd__decap_6
XTAP_TAPCELL_ROW_6_140 VGND VPWR sky130_fd_sc_hd__tapvpwrvgnd_1
XFILLER_0_3 VPWR VGND VPWR VGND sky130_ef_sc_hd__decap_12
XFILLER_47_51 VGND VGND VPWR VPWR sky130_fd_sc_hd__decap_4
X_794_ clknet_4_7_0_wr_clk _120_ VGND VGND VPWR VPWR mem\[15\]\[0\] sky130_fd_sc_hd__dfxtp_1
XTAP_TAPCELL_ROW_29_253 VGND VPWR sky130_fd_sc_hd__tapvpwrvgnd_1
XFILLER_34_217 VGND VGND VPWR VPWR sky130_fd_sc_hd__decap_4
XFILLER_6_195 VGND VGND VPWR VPWR sky130_fd_sc_hd__fill_1
XFILLER_10_191 VGND VGND VPWR VPWR sky130_fd_sc_hd__decap_4
XFILLER_33_3 VPWR VGND VPWR VGND sky130_ef_sc_hd__decap_12
XFILLER_17_21 VGND VGND VPWR VPWR sky130_fd_sc_hd__fill_1
XFILLER_17_54 VGND VGND VPWR VPWR sky130_fd_sc_hd__fill_2
Xhold5 rd_gray_sync1\[4\] VGND VGND VPWR VPWR net81 sky130_fd_sc_hd__dlygate4sd3_1
X_777_ net69 wr_gray\[3\] net72 VGND VGND VPWR VPWR wr_gray_sync1\[3\] sky130_fd_sc_hd__dfrtp_1
XFILLER_30_253 VPWR VGND VPWR VGND sky130_ef_sc_hd__decap_12
XTAP_TAPCELL_ROW_0_102 VGND VPWR sky130_fd_sc_hd__tapvpwrvgnd_1
XTAP_TAPCELL_ROW_23_226 VGND VPWR sky130_fd_sc_hd__tapvpwrvgnd_1
XFILLER_48_139 VGND VGND VPWR VPWR sky130_fd_sc_hd__fill_1
X_700_ clknet_4_10_0_wr_clk _068_ VGND VGND VPWR VPWR mem\[8\]\[4\] sky130_fd_sc_hd__dfxtp_1
XFILLER_0_113 VGND VGND VPWR VPWR sky130_fd_sc_hd__decap_8
X_493_ _137_ _210_ VGND VGND VPWR VPWR _286_ sky130_fd_sc_hd__nand2_4
XFILLER_44_301 VGND VGND VPWR VPWR sky130_fd_sc_hd__fill_1
X_562_ net65 net180 _298_ VGND VGND VPWR VPWR _072_ sky130_fd_sc_hd__mux2_1
X_631_ net192 net51 _304_ VGND VGND VPWR VPWR _135_ sky130_fd_sc_hd__mux2_1
XFILLER_28_97 VPWR VGND VPWR VGND sky130_ef_sc_hd__decap_12
XFILLER_44_85 VPWR VGND VPWR VGND sky130_ef_sc_hd__decap_12
XFILLER_12_242 VGND VGND VPWR VPWR sky130_fd_sc_hd__decap_8
XFILLER_47_161 VGND VGND VPWR VPWR sky130_fd_sc_hd__decap_6
XFILLER_35_301 VGND VGND VPWR VPWR sky130_fd_sc_hd__fill_1
XPHY_EDGE_ROW_17_Left_68 VGND VGND VPWR VPWR sky130_fd_sc_hd__decap_3
XTAP_TAPCELL_ROW_20_207 VGND VPWR sky130_fd_sc_hd__tapvpwrvgnd_1
XFILLER_26_301 VGND VGND VPWR VPWR sky130_fd_sc_hd__fill_1
XFILLER_5_249 VPWR VGND VPWR VGND sky130_ef_sc_hd__decap_12
XFILLER_30_10 VPWR VGND VPWR VGND sky130_ef_sc_hd__decap_12
X_476_ net33 _278_ _226_ VGND VGND VPWR VPWR _006_ sky130_fd_sc_hd__mux2_1
XFILLER_44_197 VPWR VGND VPWR VGND sky130_ef_sc_hd__decap_12
XTAP_TAPCELL_ROW_42_321 VGND VPWR sky130_fd_sc_hd__tapvpwrvgnd_1
X_614_ net114 net51 _303_ VGND VGND VPWR VPWR _119_ sky130_fd_sc_hd__mux2_1
X_545_ net89 net62 _295_ VGND VGND VPWR VPWR _058_ sky130_fd_sc_hd__mux2_1
XFILLER_35_197 VGND VGND VPWR VPWR sky130_fd_sc_hd__decap_6
X_330_ _147_ _159_ _160_ VGND VGND VPWR VPWR _161_ sky130_fd_sc_hd__nand3_1
XFILLER_41_145 VGND VGND VPWR VPWR sky130_fd_sc_hd__decap_4
XFILLER_26_186 VGND VGND VPWR VPWR sky130_fd_sc_hd__fill_1
XFILLER_26_197 VGND VGND VPWR VPWR sky130_fd_sc_hd__decap_6
XFILLER_49_223 VGND VGND VPWR VPWR sky130_fd_sc_hd__fill_1
X_528_ net166 net59 _293_ VGND VGND VPWR VPWR _043_ sky130_fd_sc_hd__mux2_1
X_459_ mem\[4\]\[4\] mem\[5\]\[4\] mem\[6\]\[4\] mem\[7\]\[4\] net48 net43 VGND VGND
+ VPWR VPWR _264_ sky130_fd_sc_hd__mux4_1
XFILLER_32_101 VGND VGND VPWR VPWR sky130_fd_sc_hd__fill_1
XFILLER_32_134 VGND VGND VPWR VPWR sky130_fd_sc_hd__decap_6
X_313_ net4 VGND VGND VPWR VPWR _144_ sky130_fd_sc_hd__inv_2
Xinput17 wr_data[3] VGND VGND VPWR VPWR net17 sky130_fd_sc_hd__buf_1
XFILLER_45_281 VGND VGND VPWR VPWR sky130_fd_sc_hd__decap_8
XFILLER_37_237 VPWR VGND VPWR VGND sky130_ef_sc_hd__decap_12
XTAP_TAPCELL_ROW_15_184 VGND VPWR sky130_fd_sc_hd__tapvpwrvgnd_1
XFILLER_3_90 VGND VGND VPWR VPWR sky130_fd_sc_hd__decap_6
XTAP_TAPCELL_ROW_38_298 VGND VPWR sky130_fd_sc_hd__tapvpwrvgnd_1
XPHY_EDGE_ROW_5_Left_56 VGND VGND VPWR VPWR sky130_fd_sc_hd__decap_3
XTAP_TAPCELL_ROW_6_141 VGND VPWR sky130_fd_sc_hd__tapvpwrvgnd_1
X_793_ clknet_4_15_0_wr_clk net81 net73 VGND VGND VPWR VPWR rd_bin_sync\[4\] sky130_fd_sc_hd__dfrtp_2
XTAP_TAPCELL_ROW_29_254 VGND VPWR sky130_fd_sc_hd__tapvpwrvgnd_1
XFILLER_26_3 VGND VGND VPWR VPWR sky130_fd_sc_hd__decap_8
XPHY_EDGE_ROW_47_Left_98 VGND VGND VPWR VPWR sky130_fd_sc_hd__decap_3
XTAP_TAPCELL_ROW_3_122 VGND VPWR sky130_fd_sc_hd__tapvpwrvgnd_1
Xhold6 mem\[2\]\[1\] VGND VGND VPWR VPWR net82 sky130_fd_sc_hd__dlygate4sd3_1
X_776_ net69 wr_gray\[2\] net73 VGND VGND VPWR VPWR wr_gray_sync1\[2\] sky130_fd_sc_hd__dfrtp_1
XFILLER_15_240 VPWR VGND VPWR VGND sky130_ef_sc_hd__decap_12
XFILLER_30_265 VGND VGND VPWR VPWR sky130_fd_sc_hd__decap_6
XTAP_TAPCELL_ROW_0_103 VGND VPWR sky130_fd_sc_hd__tapvpwrvgnd_1
XPHY_EDGE_ROW_3_Right_3 VGND VGND VPWR VPWR sky130_fd_sc_hd__decap_3
XFILLER_21_298 VGND VGND VPWR VPWR sky130_fd_sc_hd__fill_1
X_630_ net127 net53 _304_ VGND VGND VPWR VPWR _134_ sky130_fd_sc_hd__mux2_1
XFILLER_0_169 VGND VGND VPWR VPWR sky130_fd_sc_hd__fill_2
XFILLER_44_53 VPWR VGND VPWR VGND sky130_ef_sc_hd__decap_12
X_561_ net37 _214_ VGND VGND VPWR VPWR _298_ sky130_fd_sc_hd__nand2b_4
X_492_ net163 net51 _285_ VGND VGND VPWR VPWR _015_ sky130_fd_sc_hd__mux2_1
XFILLER_44_97 VGND VGND VPWR VPWR sky130_fd_sc_hd__decap_8
X_759_ clknet_4_13_0_wr_clk wr_bin_next\[2\] net73 VGND VGND VPWR VPWR wr_bin\[2\]
+ sky130_fd_sc_hd__dfrtp_1
XTAP_TAPCELL_ROW_20_208 VGND VPWR sky130_fd_sc_hd__tapvpwrvgnd_1
XFILLER_38_195 VGND VGND VPWR VPWR sky130_fd_sc_hd__fill_1
XFILLER_30_22 VGND VGND VPWR VPWR sky130_fd_sc_hd__decap_6
XFILLER_39_53 VGND VGND VPWR VPWR sky130_fd_sc_hd__decap_3
X_613_ net107 net53 _303_ VGND VGND VPWR VPWR _118_ sky130_fd_sc_hd__mux2_1
XPHY_EDGE_ROW_34_Left_85 VGND VGND VPWR VPWR sky130_fd_sc_hd__decap_3
X_475_ _275_ _277_ _274_ _276_ net39 net40 VGND VGND VPWR VPWR _278_ sky130_fd_sc_hd__mux4_1
X_544_ net87 net64 _295_ VGND VGND VPWR VPWR _057_ sky130_fd_sc_hd__mux2_1
XFILLER_50_113 VPWR VGND VPWR VGND sky130_ef_sc_hd__decap_12
XFILLER_35_165 VGND VGND VPWR VPWR sky130_fd_sc_hd__decap_3
XFILLER_2_209 VPWR VGND VPWR VGND sky130_ef_sc_hd__decap_12
XFILLER_41_43 VPWR VGND VPWR VGND sky130_ef_sc_hd__decap_12
XFILLER_2_15 VPWR VGND VPWR VGND sky130_ef_sc_hd__decap_12
XFILLER_49_279 VGND VGND VPWR VPWR sky130_fd_sc_hd__fill_1
X_527_ net174 net62 _293_ VGND VGND VPWR VPWR _042_ sky130_fd_sc_hd__mux2_1
X_389_ net37 _214_ VGND VGND VPWR VPWR _215_ sky130_fd_sc_hd__nor2_1
X_458_ net30 _263_ net36 VGND VGND VPWR VPWR _003_ sky130_fd_sc_hd__mux2_1
XFILLER_11_57 VGND VGND VPWR VPWR sky130_fd_sc_hd__decap_4
XFILLER_36_21 VGND VGND VPWR VPWR sky130_fd_sc_hd__decap_6
X_312_ net6 VGND VGND VPWR VPWR _143_ sky130_fd_sc_hd__inv_2
XFILLER_6_301 VGND VGND VPWR VPWR sky130_fd_sc_hd__fill_1
Xinput18 wr_data[4] VGND VGND VPWR VPWR net18 sky130_fd_sc_hd__buf_1
XFILLER_45_293 VGND VGND VPWR VPWR sky130_fd_sc_hd__decap_4
XFILLER_37_249 VGND VGND VPWR VPWR sky130_fd_sc_hd__decap_3
XFILLER_20_105 VGND VGND VPWR VPWR sky130_fd_sc_hd__decap_4
XFILLER_9_161 VGND VGND VPWR VPWR sky130_fd_sc_hd__decap_6
XFILLER_13_190 VGND VGND VPWR VPWR sky130_fd_sc_hd__decap_6
XTAP_TAPCELL_ROW_15_185 VGND VPWR sky130_fd_sc_hd__tapvpwrvgnd_1
XFILLER_20_138 VGND VGND VPWR VPWR sky130_fd_sc_hd__fill_2
XFILLER_20_149 VGND VGND VPWR VPWR sky130_fd_sc_hd__fill_2
XPHY_EDGE_ROW_21_Left_72 VGND VGND VPWR VPWR sky130_fd_sc_hd__decap_3
XTAP_TAPCELL_ROW_38_299 VGND VPWR sky130_fd_sc_hd__tapvpwrvgnd_1
XFILLER_11_149 VGND VGND VPWR VPWR sky130_fd_sc_hd__decap_3
XFILLER_22_67 VPWR VGND VPWR VGND sky130_ef_sc_hd__decap_12
X_792_ clknet_4_15_0_wr_clk net78 net74 VGND VGND VPWR VPWR rd_gray_sync2\[3\] sky130_fd_sc_hd__dfrtp_1
XFILLER_19_205 VPWR VGND VPWR VGND sky130_ef_sc_hd__decap_12
XTAP_TAPCELL_ROW_29_255 VGND VPWR sky130_fd_sc_hd__tapvpwrvgnd_1
XFILLER_6_175 VPWR VGND VPWR VGND sky130_ef_sc_hd__decap_12
XFILLER_19_3 VGND VGND VPWR VPWR sky130_fd_sc_hd__decap_6
XFILLER_18_271 VGND VGND VPWR VPWR sky130_fd_sc_hd__fill_1
XTAP_TAPCELL_ROW_3_123 VGND VPWR sky130_fd_sc_hd__tapvpwrvgnd_1
XFILLER_24_296 VGND VGND VPWR VPWR sky130_fd_sc_hd__fill_2
XFILLER_33_55 VGND VGND VPWR VPWR sky130_fd_sc_hd__fill_1
XTAP_TAPCELL_ROW_34_280 VGND VPWR sky130_fd_sc_hd__tapvpwrvgnd_1
Xhold7 mem\[14\]\[1\] VGND VGND VPWR VPWR net83 sky130_fd_sc_hd__dlygate4sd3_1
X_775_ net69 wr_gray\[1\] net73 VGND VGND VPWR VPWR wr_gray_sync1\[1\] sky130_fd_sc_hd__dfrtp_1
XFILLER_15_252 VGND VGND VPWR VPWR sky130_fd_sc_hd__decap_6
XFILLER_30_299 VGND VGND VPWR VPWR sky130_fd_sc_hd__decap_3
XTAP_TAPCELL_ROW_48_350 VGND VPWR sky130_fd_sc_hd__tapvpwrvgnd_1
XFILLER_0_81 VGND VGND VPWR VPWR sky130_fd_sc_hd__decap_3
XTAP_TAPCELL_ROW_0_104 VGND VPWR sky130_fd_sc_hd__tapvpwrvgnd_1
XFILLER_9_90 VGND VGND VPWR VPWR sky130_fd_sc_hd__decap_8
XFILLER_21_222 VGND VGND VPWR VPWR sky130_fd_sc_hd__fill_2
XFILLER_0_126 VPWR VGND VPWR VGND sky130_ef_sc_hd__decap_12
X_560_ net37 net38 VGND VGND VPWR VPWR _297_ sky130_fd_sc_hd__nand2b_2
XFILLER_28_66 VGND VGND VPWR VPWR sky130_fd_sc_hd__decap_3
XFILLER_28_77 VGND VGND VPWR VPWR sky130_fd_sc_hd__decap_6
XFILLER_44_65 VGND VGND VPWR VPWR sky130_fd_sc_hd__decap_6
X_491_ net171 net53 _285_ VGND VGND VPWR VPWR _014_ sky130_fd_sc_hd__mux2_1
XFILLER_5_15 VGND VGND VPWR VPWR sky130_fd_sc_hd__decap_8
XFILLER_12_266 VGND VGND VPWR VPWR sky130_fd_sc_hd__fill_2
X_758_ clknet_4_13_0_wr_clk wr_bin_next\[1\] net75 VGND VGND VPWR VPWR wr_bin\[1\]
+ sky130_fd_sc_hd__dfrtp_1
XPHY_EDGE_ROW_13_Right_13 VGND VGND VPWR VPWR sky130_fd_sc_hd__decap_3
X_689_ clknet_4_8_0_wr_clk _057_ VGND VGND VPWR VPWR mem\[0\]\[1\] sky130_fd_sc_hd__dfxtp_1
XTAP_TAPCELL_ROW_20_209 VGND VPWR sky130_fd_sc_hd__tapvpwrvgnd_1
XPHY_EDGE_ROW_22_Right_22 VGND VGND VPWR VPWR sky130_fd_sc_hd__decap_3
XFILLER_7_281 VPWR VGND VPWR VGND sky130_ef_sc_hd__decap_12
XFILLER_38_141 VPWR VGND VPWR VGND sky130_ef_sc_hd__decap_12
XPHY_EDGE_ROW_31_Right_31 VGND VGND VPWR VPWR sky130_fd_sc_hd__decap_3
XPHY_EDGE_ROW_40_Right_40 VGND VGND VPWR VPWR sky130_fd_sc_hd__decap_3
XFILLER_14_79 VGND VGND VPWR VPWR sky130_fd_sc_hd__decap_4
XFILLER_30_45 VPWR VGND VPWR VGND sky130_ef_sc_hd__decap_12
X_543_ net119 net65 _295_ VGND VGND VPWR VPWR _056_ sky130_fd_sc_hd__mux2_1
X_612_ net126 net55 _303_ VGND VGND VPWR VPWR _117_ sky130_fd_sc_hd__mux2_1
X_474_ mem\[8\]\[6\] mem\[9\]\[6\] mem\[10\]\[6\] mem\[11\]\[6\] net47 net44 VGND
+ VGND VPWR VPWR _277_ sky130_fd_sc_hd__mux4_1
XFILLER_4_251 VGND VGND VPWR VPWR sky130_fd_sc_hd__fill_1
XFILLER_50_147 VGND VGND VPWR VPWR sky130_fd_sc_hd__decap_3
XFILLER_50_125 VGND VGND VPWR VPWR sky130_fd_sc_hd__decap_4
Xclkbuf_4_14_0_wr_clk clknet_0_wr_clk VGND VGND VPWR VPWR clknet_4_14_0_wr_clk sky130_fd_sc_hd__clkbuf_8
XFILLER_50_169 VPWR VGND VPWR VGND sky130_ef_sc_hd__decap_12
XFILLER_41_169 VGND VGND VPWR VPWR sky130_fd_sc_hd__fill_2
XFILLER_41_55 VGND VGND VPWR VPWR sky130_fd_sc_hd__fill_1
XFILLER_49_225 VPWR VGND VPWR VGND sky130_ef_sc_hd__decap_12
XFILLER_2_27 VGND VGND VPWR VPWR sky130_fd_sc_hd__fill_1
X_526_ net92 net64 _293_ VGND VGND VPWR VPWR _041_ sky130_fd_sc_hd__mux2_1
X_388_ _213_ _214_ VGND VGND VPWR VPWR wr_bin_next\[2\] sky130_fd_sc_hd__nor2_1
X_457_ _260_ _262_ _259_ _261_ net39 net40 VGND VGND VPWR VPWR _263_ sky130_fd_sc_hd__mux4_1
XFILLER_49_3 VPWR VGND VPWR VGND sky130_ef_sc_hd__decap_12
XFILLER_46_217 VGND VGND VPWR VPWR sky130_fd_sc_hd__decap_4
XFILLER_36_66 VGND VGND VPWR VPWR sky130_fd_sc_hd__fill_2
X_311_ net7 VGND VGND VPWR VPWR _142_ sky130_fd_sc_hd__inv_2
Xinput19 wr_data[5] VGND VGND VPWR VPWR net19 sky130_fd_sc_hd__buf_1
X_509_ net141 net58 _289_ VGND VGND VPWR VPWR _028_ sky130_fd_sc_hd__mux2_1
XTAP_TAPCELL_ROW_15_186 VGND VPWR sky130_fd_sc_hd__tapvpwrvgnd_1
XFILLER_9_140 VGND VGND VPWR VPWR sky130_fd_sc_hd__fill_1
XFILLER_9_173 VGND VGND VPWR VPWR sky130_fd_sc_hd__fill_1
XFILLER_28_206 VGND VGND VPWR VPWR sky130_fd_sc_hd__decap_6
XFILLER_11_106 VGND VGND VPWR VPWR sky130_fd_sc_hd__decap_3
XFILLER_22_79 VGND VGND VPWR VPWR sky130_fd_sc_hd__decap_4
X_791_ clknet_4_15_0_wr_clk net79 net74 VGND VGND VPWR VPWR full_compare\[2\] sky130_fd_sc_hd__dfrtp_1
XFILLER_19_217 VGND VGND VPWR VPWR sky130_fd_sc_hd__decap_6
XFILLER_42_253 VPWR VGND VPWR VGND sky130_ef_sc_hd__decap_12
XFILLER_42_220 VGND VGND VPWR VPWR sky130_fd_sc_hd__fill_1
XFILLER_8_15 VPWR VGND VPWR VGND sky130_ef_sc_hd__decap_12
XFILLER_27_250 VPWR VGND VPWR VGND sky130_ef_sc_hd__decap_12
XTAP_TAPCELL_ROW_29_256 VGND VPWR sky130_fd_sc_hd__tapvpwrvgnd_1
XFILLER_6_165 VGND VGND VPWR VPWR sky130_fd_sc_hd__fill_2
XFILLER_10_161 VGND VGND VPWR VPWR sky130_fd_sc_hd__decap_8
XTAP_TAPCELL_ROW_12_167 VGND VPWR sky130_fd_sc_hd__tapvpwrvgnd_1
XFILLER_6_187 VGND VGND VPWR VPWR sky130_fd_sc_hd__decap_8
Xclkbuf_4_2_0_wr_clk clknet_0_wr_clk VGND VGND VPWR VPWR clknet_4_2_0_wr_clk sky130_fd_sc_hd__clkbuf_8
XTAP_TAPCELL_ROW_3_124 VGND VPWR sky130_fd_sc_hd__tapvpwrvgnd_1
XFILLER_24_253 VGND VGND VPWR VPWR sky130_fd_sc_hd__fill_1
XTAP_TAPCELL_ROW_26_237 VGND VPWR sky130_fd_sc_hd__tapvpwrvgnd_1
XPHY_EDGE_ROW_49_Left_100 VGND VGND VPWR VPWR sky130_fd_sc_hd__decap_3
XTAP_TAPCELL_ROW_34_281 VGND VPWR sky130_fd_sc_hd__tapvpwrvgnd_1
XFILLER_47_301 VGND VGND VPWR VPWR sky130_fd_sc_hd__fill_1
X_774_ net68 wr_gray\[0\] net70 VGND VGND VPWR VPWR wr_gray_sync1\[0\] sky130_fd_sc_hd__dfrtp_1
Xhold8 mem\[12\]\[1\] VGND VGND VPWR VPWR net84 sky130_fd_sc_hd__dlygate4sd3_1
XFILLER_38_301 VGND VGND VPWR VPWR sky130_fd_sc_hd__fill_1
XFILLER_31_3 VGND VGND VPWR VPWR sky130_fd_sc_hd__fill_2
XTAP_TAPCELL_ROW_48_351 VGND VPWR sky130_fd_sc_hd__tapvpwrvgnd_1
XTAP_TAPCELL_ROW_0_105 VGND VPWR sky130_fd_sc_hd__tapvpwrvgnd_1
XTAP_TAPCELL_ROW_31_262 VGND VPWR sky130_fd_sc_hd__tapvpwrvgnd_1
XFILLER_0_138 VGND VGND VPWR VPWR sky130_fd_sc_hd__fill_2
X_490_ net153 net55 _285_ VGND VGND VPWR VPWR _013_ sky130_fd_sc_hd__mux2_1
X_757_ clknet_4_13_0_wr_clk wr_bin_next\[0\] net75 VGND VGND VPWR VPWR wr_bin\[0\]
+ sky130_fd_sc_hd__dfrtp_1
XTAP_TAPCELL_ROW_45_332 VGND VPWR sky130_fd_sc_hd__tapvpwrvgnd_1
X_688_ clknet_4_12_0_wr_clk _056_ VGND VGND VPWR VPWR mem\[0\]\[0\] sky130_fd_sc_hd__dfxtp_1
XFILLER_7_293 VGND VGND VPWR VPWR sky130_fd_sc_hd__decap_8
XFILLER_38_153 VPWR VGND VPWR VGND sky130_ef_sc_hd__decap_12
XFILLER_30_35 VGND VGND VPWR VPWR sky130_fd_sc_hd__fill_1
XFILLER_30_57 VGND VGND VPWR VPWR sky130_fd_sc_hd__fill_2
X_473_ mem\[12\]\[6\] mem\[13\]\[6\] mem\[14\]\[6\] mem\[15\]\[6\] net47 net44 VGND
+ VGND VPWR VPWR _276_ sky130_fd_sc_hd__mux4_1
X_611_ net157 net58 _303_ VGND VGND VPWR VPWR _116_ sky130_fd_sc_hd__mux2_1
X_542_ _288_ _292_ VGND VGND VPWR VPWR _295_ sky130_fd_sc_hd__nor2_4
X_809_ clknet_4_0_0_wr_clk _135_ VGND VGND VPWR VPWR mem\[9\]\[7\] sky130_fd_sc_hd__dfxtp_1
XFILLER_35_178 VGND VGND VPWR VPWR sky130_fd_sc_hd__fill_1
XFILLER_26_134 VGND VGND VPWR VPWR sky130_fd_sc_hd__decap_6
XFILLER_26_156 VPWR VGND VPWR VGND sky130_ef_sc_hd__decap_12
XFILLER_25_57 VGND VGND VPWR VPWR sky130_fd_sc_hd__fill_1
XFILLER_9_3 VPWR VGND VPWR VGND sky130_ef_sc_hd__decap_12
XFILLER_49_237 VPWR VGND VPWR VGND sky130_ef_sc_hd__decap_12
XFILLER_49_215 VGND VGND VPWR VPWR sky130_fd_sc_hd__decap_8
X_525_ net172 net65 _293_ VGND VGND VPWR VPWR _040_ sky130_fd_sc_hd__mux2_1
X_456_ mem\[8\]\[3\] mem\[9\]\[3\] mem\[10\]\[3\] mem\[11\]\[3\] net46 net42 VGND
+ VGND VPWR VPWR _262_ sky130_fd_sc_hd__mux4_1
X_387_ net38 _211_ VGND VGND VPWR VPWR _214_ sky130_fd_sc_hd__and2_1
XFILLER_46_229 VGND VGND VPWR VPWR sky130_fd_sc_hd__fill_2
XFILLER_46_207 VGND VGND VPWR VPWR sky130_fd_sc_hd__decap_6
X_310_ net8 VGND VGND VPWR VPWR _141_ sky130_fd_sc_hd__inv_2
XFILLER_36_45 VGND VGND VPWR VPWR sky130_fd_sc_hd__decap_4
XFILLER_14_115 VGND VGND VPWR VPWR sky130_fd_sc_hd__decap_6
XTAP_TAPCELL_ROW_9_152 VGND VPWR sky130_fd_sc_hd__tapvpwrvgnd_1
XFILLER_20_118 VGND VGND VPWR VPWR sky130_fd_sc_hd__decap_3
X_508_ net94 net60 _289_ VGND VGND VPWR VPWR _027_ sky130_fd_sc_hd__mux2_1
X_439_ mem\[4\]\[1\] mem\[5\]\[1\] mem\[6\]\[1\] mem\[7\]\[1\] net48 net43 VGND VGND
+ VPWR VPWR _247_ sky130_fd_sc_hd__mux4_1
XFILLER_47_55 VGND VGND VPWR VPWR sky130_fd_sc_hd__fill_1
X_790_ clknet_4_13_0_wr_clk net80 net73 VGND VGND VPWR VPWR full_compare\[1\] sky130_fd_sc_hd__dfrtp_1
XFILLER_27_262 VPWR VGND VPWR VGND sky130_ef_sc_hd__decap_12
XFILLER_42_265 VPWR VGND VPWR VGND sky130_ef_sc_hd__decap_12
XFILLER_8_49 VGND VGND VPWR VPWR sky130_fd_sc_hd__decap_3
XFILLER_8_27 VGND VGND VPWR VPWR sky130_fd_sc_hd__fill_1
XFILLER_10_195 VGND VGND VPWR VPWR sky130_fd_sc_hd__fill_1
XTAP_TAPCELL_ROW_12_168 VGND VPWR sky130_fd_sc_hd__tapvpwrvgnd_1
XFILLER_33_221 VGND VGND VPWR VPWR sky130_fd_sc_hd__decap_3
XTAP_TAPCELL_ROW_3_125 VGND VPWR sky130_fd_sc_hd__tapvpwrvgnd_1
XTAP_TAPCELL_ROW_26_238 VGND VPWR sky130_fd_sc_hd__tapvpwrvgnd_1
XFILLER_33_68 VGND VGND VPWR VPWR sky130_fd_sc_hd__decap_6
Xhold9 mem\[13\]\[3\] VGND VGND VPWR VPWR net85 sky130_fd_sc_hd__dlygate4sd3_1
X_773_ clknet_4_14_0_wr_clk wr_gray_next\[3\] net74 VGND VGND VPWR VPWR wr_gray\[3\]
+ sky130_fd_sc_hd__dfrtp_1
XFILLER_2_191 VGND VGND VPWR VPWR sky130_fd_sc_hd__decap_4
XTAP_TAPCELL_ROW_0_106 VGND VPWR sky130_fd_sc_hd__tapvpwrvgnd_1
XFILLER_24_3 VPWR VGND VPWR VGND sky130_ef_sc_hd__decap_12
XFILLER_21_279 VGND VGND VPWR VPWR sky130_fd_sc_hd__fill_1
XTAP_TAPCELL_ROW_31_263 VGND VPWR sky130_fd_sc_hd__tapvpwrvgnd_1
X_756_ clknet_4_15_0_wr_clk afull_next net74 VGND VGND VPWR VPWR net24 sky130_fd_sc_hd__dfrtp_1
XTAP_TAPCELL_ROW_45_333 VGND VPWR sky130_fd_sc_hd__tapvpwrvgnd_1
X_687_ clknet_4_1_0_wr_clk _055_ VGND VGND VPWR VPWR mem\[10\]\[7\] sky130_fd_sc_hd__dfxtp_1
XFILLER_7_261 VPWR VGND VPWR VGND sky130_ef_sc_hd__decap_12
XPHY_EDGE_ROW_7_Right_7 VGND VGND VPWR VPWR sky130_fd_sc_hd__decap_3
XFILLER_38_165 VGND VGND VPWR VPWR sky130_fd_sc_hd__decap_4
XFILLER_14_15 VPWR VGND VPWR VGND sky130_ef_sc_hd__decap_12
XFILLER_14_37 VGND VGND VPWR VPWR sky130_fd_sc_hd__decap_3
XFILLER_14_48 VGND VGND VPWR VPWR sky130_fd_sc_hd__decap_6
XFILLER_39_45 VGND VGND VPWR VPWR sky130_fd_sc_hd__decap_8
X_610_ net95 net60 _303_ VGND VGND VPWR VPWR _115_ sky130_fd_sc_hd__mux2_1
XFILLER_29_110 VGND VGND VPWR VPWR sky130_fd_sc_hd__fill_2
XFILLER_44_124 VGND VGND VPWR VPWR sky130_fd_sc_hd__decap_8
X_472_ mem\[0\]\[6\] mem\[1\]\[6\] mem\[2\]\[6\] mem\[3\]\[6\] net47 net45 VGND VGND
+ VPWR VPWR _275_ sky130_fd_sc_hd__mux4_1
X_541_ net97 net51 _294_ VGND VGND VPWR VPWR _055_ sky130_fd_sc_hd__mux2_1
XFILLER_29_165 VGND VGND VPWR VPWR sky130_fd_sc_hd__decap_3
XFILLER_4_253 VPWR VGND VPWR VGND sky130_ef_sc_hd__decap_12
X_808_ clknet_4_5_0_wr_clk _134_ VGND VGND VPWR VPWR mem\[9\]\[6\] sky130_fd_sc_hd__dfxtp_1
XFILLER_35_124 VGND VGND VPWR VPWR sky130_fd_sc_hd__decap_4
X_739_ clknet_4_4_0_wr_clk _106_ VGND VGND VPWR VPWR mem\[5\]\[2\] sky130_fd_sc_hd__dfxtp_1
XFILLER_25_47 VGND VGND VPWR VPWR sky130_fd_sc_hd__fill_1
XFILLER_26_168 VPWR VGND VPWR VGND sky130_ef_sc_hd__decap_12
XPHY_EDGE_ROW_38_Left_89 VGND VGND VPWR VPWR sky130_fd_sc_hd__decap_3
XFILLER_49_205 VGND VGND VPWR VPWR sky130_fd_sc_hd__decap_4
XFILLER_1_223 VGND VGND VPWR VPWR sky130_fd_sc_hd__fill_1
XFILLER_49_249 VPWR VGND VPWR VGND sky130_ef_sc_hd__decap_12
XFILLER_2_29 VPWR VGND VPWR VGND sky130_ef_sc_hd__decap_12
X_386_ net38 _211_ VGND VGND VPWR VPWR _213_ sky130_fd_sc_hd__nor2_1
XFILLER_9_301 VGND VGND VPWR VPWR sky130_fd_sc_hd__fill_1
XFILLER_15_91 VPWR VGND VPWR VGND sky130_ef_sc_hd__decap_12
X_455_ mem\[12\]\[3\] mem\[13\]\[3\] mem\[14\]\[3\] mem\[15\]\[3\] net46 net42 VGND
+ VGND VPWR VPWR _261_ sky130_fd_sc_hd__mux4_1
X_524_ _286_ _292_ VGND VGND VPWR VPWR _293_ sky130_fd_sc_hd__nor2_4
XFILLER_14_138 VGND VGND VPWR VPWR sky130_fd_sc_hd__fill_2
XTAP_TAPCELL_ROW_9_153 VGND VPWR sky130_fd_sc_hd__tapvpwrvgnd_1
XFILLER_37_208 VPWR VGND VPWR VGND sky130_ef_sc_hd__decap_12
X_438_ net27 _246_ _226_ VGND VGND VPWR VPWR _000_ sky130_fd_sc_hd__mux2_1
X_369_ net3 _188_ _198_ VGND VGND VPWR VPWR _199_ sky130_fd_sc_hd__or3_1
X_507_ net110 net62 _289_ VGND VGND VPWR VPWR _026_ sky130_fd_sc_hd__mux2_1
XFILLER_42_277 VPWR VGND VPWR VGND sky130_ef_sc_hd__decap_12
XTAP_TAPCELL_ROW_12_169 VGND VPWR sky130_fd_sc_hd__tapvpwrvgnd_1
XPHY_EDGE_ROW_25_Left_76 VGND VGND VPWR VPWR sky130_fd_sc_hd__decap_3
XTAP_TAPCELL_ROW_3_126 VGND VPWR sky130_fd_sc_hd__tapvpwrvgnd_1
XTAP_TAPCELL_ROW_26_239 VGND VPWR sky130_fd_sc_hd__tapvpwrvgnd_1
XFILLER_33_25 VGND VGND VPWR VPWR sky130_fd_sc_hd__decap_4
X_772_ clknet_4_12_0_wr_clk wr_gray_next\[2\] net73 VGND VGND VPWR VPWR wr_gray\[2\]
+ sky130_fd_sc_hd__dfrtp_1
XFILLER_15_288 VGND VGND VPWR VPWR sky130_fd_sc_hd__decap_6
XTAP_TAPCELL_ROW_0_107 VGND VPWR sky130_fd_sc_hd__tapvpwrvgnd_1
XFILLER_17_3 VGND VGND VPWR VPWR sky130_fd_sc_hd__fill_2
XFILLER_21_225 VPWR VGND VPWR VGND sky130_ef_sc_hd__decap_12
XTAP_TAPCELL_ROW_31_264 VGND VPWR sky130_fd_sc_hd__tapvpwrvgnd_1
XFILLER_28_25 VGND VGND VPWR VPWR sky130_fd_sc_hd__decap_3
XFILLER_28_58 VGND VGND VPWR VPWR sky130_fd_sc_hd__decap_8
XFILLER_8_218 VPWR VGND VPWR VGND sky130_ef_sc_hd__decap_12
XTAP_TAPCELL_ROW_22_220 VGND VPWR sky130_fd_sc_hd__tapvpwrvgnd_1
X_755_ clknet_4_13_0_wr_clk full_next net74 VGND VGND VPWR VPWR net26 sky130_fd_sc_hd__dfrtp_1
XFILLER_47_122 VGND VGND VPWR VPWR sky130_fd_sc_hd__decap_6
XFILLER_47_111 VGND VGND VPWR VPWR sky130_fd_sc_hd__fill_1
XTAP_TAPCELL_ROW_45_334 VGND VPWR sky130_fd_sc_hd__tapvpwrvgnd_1
X_686_ clknet_4_5_0_wr_clk _054_ VGND VGND VPWR VPWR mem\[10\]\[6\] sky130_fd_sc_hd__dfxtp_1
XFILLER_7_273 VGND VGND VPWR VPWR sky130_fd_sc_hd__decap_6
XPHY_EDGE_ROW_12_Left_63 VGND VGND VPWR VPWR sky130_fd_sc_hd__decap_3
XFILLER_14_27 VGND VGND VPWR VPWR sky130_fd_sc_hd__fill_1
X_540_ net154 net53 _294_ VGND VGND VPWR VPWR _054_ sky130_fd_sc_hd__mux2_1
XFILLER_39_57 VPWR VGND VPWR VGND sky130_ef_sc_hd__decap_12
XFILLER_39_35 VGND VGND VPWR VPWR sky130_fd_sc_hd__fill_2
XFILLER_29_177 VGND VGND VPWR VPWR sky130_fd_sc_hd__fill_2
X_471_ mem\[4\]\[6\] mem\[5\]\[6\] mem\[6\]\[6\] mem\[7\]\[6\] net47 net44 VGND VGND
+ VPWR VPWR _274_ sky130_fd_sc_hd__mux4_1
XFILLER_4_221 VPWR VGND VPWR VGND sky130_ef_sc_hd__decap_12
XFILLER_4_265 VPWR VGND VPWR VGND sky130_ef_sc_hd__decap_12
X_669_ clknet_4_0_0_wr_clk _037_ VGND VGND VPWR VPWR mem\[11\]\[5\] sky130_fd_sc_hd__dfxtp_1
X_807_ clknet_4_0_0_wr_clk _133_ VGND VGND VPWR VPWR mem\[9\]\[5\] sky130_fd_sc_hd__dfxtp_1
Xhold90 mem\[1\]\[3\] VGND VGND VPWR VPWR net166 sky130_fd_sc_hd__dlygate4sd3_1
X_738_ clknet_4_8_0_wr_clk _105_ VGND VGND VPWR VPWR mem\[5\]\[1\] sky130_fd_sc_hd__dfxtp_1
XFILLER_29_90 VPWR VGND VPWR VGND sky130_ef_sc_hd__decap_12
XFILLER_50_139 VGND VGND VPWR VPWR sky130_fd_sc_hd__fill_1
XFILLER_6_83 VGND VGND VPWR VPWR sky130_fd_sc_hd__fill_1
XFILLER_25_15 VPWR VGND VPWR VGND sky130_ef_sc_hd__decap_12
XFILLER_1_279 VGND VGND VPWR VPWR sky130_fd_sc_hd__fill_1
X_523_ net37 net38 VGND VGND VPWR VPWR _292_ sky130_fd_sc_hd__or2_2
XFILLER_17_169 VGND VGND VPWR VPWR sky130_fd_sc_hd__decap_4
X_385_ _211_ _212_ VGND VGND VPWR VPWR wr_bin_next\[1\] sky130_fd_sc_hd__nor2_1
X_454_ mem\[0\]\[3\] mem\[1\]\[3\] mem\[2\]\[3\] mem\[3\]\[3\] net50 net42 VGND VGND
+ VPWR VPWR _260_ sky130_fd_sc_hd__mux4_1
XTAP_TAPCELL_ROW_18_197 VGND VPWR sky130_fd_sc_hd__tapvpwrvgnd_1
XTAP_TAPCELL_ROW_9_154 VGND VPWR sky130_fd_sc_hd__tapvpwrvgnd_1
XFILLER_45_297 VGND VGND VPWR VPWR sky130_fd_sc_hd__fill_1
X_506_ net84 net64 _289_ VGND VGND VPWR VPWR _025_ sky130_fd_sc_hd__mux2_1
X_437_ _243_ _245_ _242_ _244_ net39 net40 VGND VGND VPWR VPWR _246_ sky130_fd_sc_hd__mux4_1
X_368_ _182_ _185_ _187_ VGND VGND VPWR VPWR _198_ sky130_fd_sc_hd__nor3b_1
XFILLER_20_109 VGND VGND VPWR VPWR sky130_fd_sc_hd__fill_1
XFILLER_47_3 VPWR VGND VPWR VGND sky130_ef_sc_hd__decap_12
XFILLER_36_253 VGND VGND VPWR VPWR sky130_fd_sc_hd__decap_4
XFILLER_36_231 VPWR VGND VPWR VGND sky130_ef_sc_hd__decap_12
XFILLER_22_27 VGND VGND VPWR VPWR sky130_fd_sc_hd__fill_1
XFILLER_47_57 VPWR VGND VPWR VGND sky130_ef_sc_hd__decap_12
XTAP_TAPCELL_ROW_37_292 VGND VPWR sky130_fd_sc_hd__tapvpwrvgnd_1
XPHY_EDGE_ROW_29_Right_29 VGND VGND VPWR VPWR sky130_fd_sc_hd__decap_3
XFILLER_42_289 VPWR VGND VPWR VGND sky130_ef_sc_hd__decap_12
XPHY_EDGE_ROW_38_Right_38 VGND VGND VPWR VPWR sky130_fd_sc_hd__decap_3
XFILLER_8_29 VPWR VGND VPWR VGND sky130_ef_sc_hd__decap_12
XFILLER_6_157 VGND VGND VPWR VPWR sky130_fd_sc_hd__decap_8
XPHY_EDGE_ROW_0_Left_51 VGND VGND VPWR VPWR sky130_fd_sc_hd__decap_3
XFILLER_12_93 VGND VGND VPWR VPWR sky130_fd_sc_hd__decap_4
XPHY_EDGE_ROW_47_Right_47 VGND VGND VPWR VPWR sky130_fd_sc_hd__decap_3
XFILLER_18_253 VPWR VGND VPWR VGND sky130_ef_sc_hd__decap_12
XFILLER_33_278 VGND VGND VPWR VPWR sky130_fd_sc_hd__fill_2
XFILLER_33_15 VGND VGND VPWR VPWR sky130_fd_sc_hd__fill_1
XPHY_EDGE_ROW_42_Left_93 VGND VGND VPWR VPWR sky130_fd_sc_hd__decap_3
XFILLER_3_138 VPWR VGND VPWR VGND sky130_ef_sc_hd__decap_12
X_771_ clknet_4_12_0_wr_clk wr_gray_next\[1\] net73 VGND VGND VPWR VPWR wr_gray\[1\]
+ sky130_fd_sc_hd__dfrtp_1
XFILLER_15_223 VGND VGND VPWR VPWR sky130_fd_sc_hd__fill_1
XFILLER_15_267 VPWR VGND VPWR VGND sky130_ef_sc_hd__decap_12
XFILLER_0_41 VPWR VGND VPWR VGND sky130_ef_sc_hd__decap_12
XFILLER_0_85 VPWR VGND VPWR VGND sky130_ef_sc_hd__decap_12
XTAP_TAPCELL_ROW_0_108 VGND VPWR sky130_fd_sc_hd__tapvpwrvgnd_1
XFILLER_21_237 VPWR VGND VPWR VGND sky130_ef_sc_hd__decap_12
XTAP_TAPCELL_ROW_31_265 VGND VPWR sky130_fd_sc_hd__tapvpwrvgnd_1
XTAP_TAPCELL_ROW_22_221 VGND VPWR sky130_fd_sc_hd__tapvpwrvgnd_1
XFILLER_47_167 VGND VGND VPWR VPWR sky130_fd_sc_hd__fill_1
XTAP_TAPCELL_ROW_45_335 VGND VPWR sky130_fd_sc_hd__tapvpwrvgnd_1
X_754_ net69 rd_gray_next\[3\] net72 VGND VGND VPWR VPWR rd_gray\[3\] sky130_fd_sc_hd__dfrtp_1
X_685_ clknet_4_0_0_wr_clk _053_ VGND VGND VPWR VPWR mem\[10\]\[5\] sky130_fd_sc_hd__dfxtp_1
XFILLER_39_69 VGND VGND VPWR VPWR sky130_fd_sc_hd__decap_3
XTAP_TAPCELL_ROW_50_360 VGND VPWR sky130_fd_sc_hd__tapvpwrvgnd_1
X_470_ net32 _273_ net36 VGND VGND VPWR VPWR _005_ sky130_fd_sc_hd__mux2_1
XFILLER_4_233 VPWR VGND VPWR VGND sky130_ef_sc_hd__decap_12
XFILLER_4_277 VPWR VGND VPWR VGND sky130_ef_sc_hd__decap_12
X_806_ clknet_4_10_0_wr_clk _132_ VGND VGND VPWR VPWR mem\[9\]\[4\] sky130_fd_sc_hd__dfxtp_1
XFILLER_20_82 VGND VGND VPWR VPWR sky130_fd_sc_hd__fill_2
XFILLER_20_93 VGND VGND VPWR VPWR sky130_fd_sc_hd__decap_3
Xhold80 mem\[13\]\[0\] VGND VGND VPWR VPWR net156 sky130_fd_sc_hd__dlygate4sd3_1
X_737_ clknet_4_7_0_wr_clk _104_ VGND VGND VPWR VPWR mem\[5\]\[0\] sky130_fd_sc_hd__dfxtp_1
Xhold91 mem\[11\]\[5\] VGND VGND VPWR VPWR net167 sky130_fd_sc_hd__dlygate4sd3_1
X_668_ clknet_4_10_0_wr_clk _036_ VGND VGND VPWR VPWR mem\[11\]\[4\] sky130_fd_sc_hd__dfxtp_1
X_599_ net165 net63 _302_ VGND VGND VPWR VPWR _105_ sky130_fd_sc_hd__mux2_1
XFILLER_25_27 VPWR VGND VPWR VGND sky130_ef_sc_hd__decap_12
XFILLER_1_203 VPWR VGND VPWR VGND sky130_ef_sc_hd__decap_12
XFILLER_1_225 VPWR VGND VPWR VGND sky130_ef_sc_hd__decap_12
X_453_ mem\[4\]\[3\] mem\[5\]\[3\] mem\[6\]\[3\] mem\[7\]\[3\] net46 net42 VGND VGND
+ VPWR VPWR _259_ sky130_fd_sc_hd__mux4_1
X_522_ net51 net208 _291_ VGND VGND VPWR VPWR _039_ sky130_fd_sc_hd__mux2_1
X_384_ wr_bin\[1\] _210_ VGND VGND VPWR VPWR _212_ sky130_fd_sc_hd__nor2_1
XFILLER_40_162 VPWR VGND VPWR VGND sky130_ef_sc_hd__decap_12
XFILLER_25_181 VPWR VGND VPWR VGND sky130_ef_sc_hd__decap_12
XFILLER_48_262 VPWR VGND VPWR VGND sky130_ef_sc_hd__decap_12
XTAP_TAPCELL_ROW_18_198 VGND VPWR sky130_fd_sc_hd__tapvpwrvgnd_1
Xclkbuf_4_5_0_wr_clk clknet_0_wr_clk VGND VGND VPWR VPWR clknet_4_5_0_wr_clk sky130_fd_sc_hd__clkbuf_8
XFILLER_7_3 VPWR VGND VPWR VGND sky130_ef_sc_hd__decap_12
XTAP_TAPCELL_ROW_9_155 VGND VPWR sky130_fd_sc_hd__tapvpwrvgnd_1
X_505_ net152 net66 _289_ VGND VGND VPWR VPWR _024_ sky130_fd_sc_hd__mux2_1
X_436_ mem\[8\]\[0\] mem\[9\]\[0\] mem\[10\]\[0\] mem\[11\]\[0\] net49 net45 VGND
+ VGND VPWR VPWR _245_ sky130_fd_sc_hd__mux4_1
XFILLER_9_122 VPWR VGND VPWR VGND sky130_ef_sc_hd__decap_12
XFILLER_13_162 VGND VGND VPWR VPWR sky130_fd_sc_hd__decap_6
X_367_ _189_ _196_ _144_ VGND VGND VPWR VPWR _197_ sky130_fd_sc_hd__a21o_1
XFILLER_3_52 VGND VGND VPWR VPWR sky130_fd_sc_hd__decap_4
XFILLER_36_243 VGND VGND VPWR VPWR sky130_fd_sc_hd__fill_2
XFILLER_36_210 VGND VGND VPWR VPWR sky130_fd_sc_hd__fill_1
XFILLER_47_69 VPWR VGND VPWR VGND sky130_ef_sc_hd__decap_12
XFILLER_27_210 VPWR VGND VPWR VGND sky130_ef_sc_hd__decap_12
XFILLER_42_224 VPWR VGND VPWR VGND sky130_ef_sc_hd__decap_12
XTAP_TAPCELL_ROW_37_293 VGND VPWR sky130_fd_sc_hd__tapvpwrvgnd_1
XFILLER_18_265 VGND VGND VPWR VPWR sky130_fd_sc_hd__decap_6
X_419_ net43 _227_ VGND VGND VPWR VPWR rd_gray_next\[0\] sky130_fd_sc_hd__xnor2_1
X_770_ clknet_4_12_0_wr_clk wr_gray_next\[0\] net73 VGND VGND VPWR VPWR wr_gray\[0\]
+ sky130_fd_sc_hd__dfrtp_1
XFILLER_15_279 VGND VGND VPWR VPWR sky130_fd_sc_hd__fill_1
XFILLER_30_205 VGND VGND VPWR VPWR sky130_fd_sc_hd__decap_4
XFILLER_2_161 VGND VGND VPWR VPWR sky130_fd_sc_hd__decap_4
XFILLER_0_53 VGND VGND VPWR VPWR sky130_fd_sc_hd__decap_3
XFILLER_0_97 VPWR VGND VPWR VGND sky130_ef_sc_hd__decap_12
XTAP_TAPCELL_ROW_0_109 VGND VPWR sky130_fd_sc_hd__tapvpwrvgnd_1
XFILLER_21_249 VGND VGND VPWR VPWR sky130_fd_sc_hd__decap_8
XTAP_TAPCELL_ROW_31_266 VGND VPWR sky130_fd_sc_hd__tapvpwrvgnd_1
XFILLER_0_109 VGND VGND VPWR VPWR sky130_fd_sc_hd__decap_3
XFILLER_44_15 VGND VGND VPWR VPWR sky130_fd_sc_hd__decap_4
XTAP_TAPCELL_ROW_45_336 VGND VPWR sky130_fd_sc_hd__tapvpwrvgnd_1
X_684_ clknet_4_10_0_wr_clk _052_ VGND VGND VPWR VPWR mem\[10\]\[4\] sky130_fd_sc_hd__dfxtp_1
X_753_ net69 rd_gray_next\[2\] net72 VGND VGND VPWR VPWR rd_gray\[2\] sky130_fd_sc_hd__dfrtp_1
XFILLER_7_220 VGND VGND VPWR VPWR sky130_fd_sc_hd__decap_4
XFILLER_39_15 VGND VGND VPWR VPWR sky130_fd_sc_hd__decap_4
XFILLER_29_102 VGND VGND VPWR VPWR sky130_fd_sc_hd__decap_8
XFILLER_44_105 VGND VGND VPWR VPWR sky130_fd_sc_hd__decap_3
XFILLER_29_113 VPWR VGND VPWR VGND sky130_ef_sc_hd__decap_12
XTAP_TAPCELL_ROW_50_361 VGND VPWR sky130_fd_sc_hd__tapvpwrvgnd_1
XTAP_TAPCELL_ROW_42_317 VGND VPWR sky130_fd_sc_hd__tapvpwrvgnd_1
XFILLER_4_289 VPWR VGND VPWR VGND sky130_ef_sc_hd__decap_12
XFILLER_4_245 VGND VGND VPWR VPWR sky130_fd_sc_hd__decap_6
Xhold70 mem\[8\]\[5\] VGND VGND VPWR VPWR net146 sky130_fd_sc_hd__dlygate4sd3_1
X_805_ clknet_4_2_0_wr_clk _131_ VGND VGND VPWR VPWR mem\[9\]\[3\] sky130_fd_sc_hd__dfxtp_1
Xhold81 mem\[4\]\[4\] VGND VGND VPWR VPWR net157 sky130_fd_sc_hd__dlygate4sd3_1
X_736_ net67 empty_next net70 VGND VGND VPWR VPWR net25 sky130_fd_sc_hd__dfstp_1
Xhold92 mem\[5\]\[2\] VGND VGND VPWR VPWR net168 sky130_fd_sc_hd__dlygate4sd3_1
X_598_ net86 net65 _302_ VGND VGND VPWR VPWR _104_ sky130_fd_sc_hd__mux2_1
X_667_ clknet_4_2_0_wr_clk _035_ VGND VGND VPWR VPWR mem\[11\]\[3\] sky130_fd_sc_hd__dfxtp_1
XFILLER_25_39 VGND VGND VPWR VPWR sky130_fd_sc_hd__decap_8
XFILLER_1_215 VGND VGND VPWR VPWR sky130_fd_sc_hd__decap_8
XFILLER_1_237 VPWR VGND VPWR VGND sky130_ef_sc_hd__decap_12
X_383_ wr_bin\[1\] wr_bin\[0\] _208_ VGND VGND VPWR VPWR _211_ sky130_fd_sc_hd__and3_2
X_521_ net53 net196 _291_ VGND VGND VPWR VPWR _038_ sky130_fd_sc_hd__mux2_1
XFILLER_17_138 VPWR VGND VPWR VGND sky130_ef_sc_hd__decap_12
XFILLER_25_193 VGND VGND VPWR VPWR sky130_fd_sc_hd__decap_8
X_452_ net29 _258_ net36 VGND VGND VPWR VPWR _002_ sky130_fd_sc_hd__mux2_1
XFILLER_40_174 VGND VGND VPWR VPWR sky130_fd_sc_hd__decap_4
XFILLER_15_61 VGND VGND VPWR VPWR sky130_fd_sc_hd__fill_1
XFILLER_48_274 VPWR VGND VPWR VGND sky130_ef_sc_hd__decap_12
XFILLER_0_281 VPWR VGND VPWR VGND sky130_ef_sc_hd__decap_12
X_719_ clknet_4_1_0_wr_clk _087_ VGND VGND VPWR VPWR mem\[6\]\[7\] sky130_fd_sc_hd__dfxtp_1
XTAP_TAPCELL_ROW_18_199 VGND VPWR sky130_fd_sc_hd__tapvpwrvgnd_1
XFILLER_23_108 VGND VGND VPWR VPWR sky130_fd_sc_hd__decap_4
XFILLER_31_196 VGND VGND VPWR VPWR sky130_fd_sc_hd__decap_3
XFILLER_36_49 VGND VGND VPWR VPWR sky130_fd_sc_hd__fill_1
XFILLER_36_27 VGND VGND VPWR VPWR sky130_fd_sc_hd__fill_1
XTAP_TAPCELL_ROW_9_156 VGND VPWR sky130_fd_sc_hd__tapvpwrvgnd_1
XFILLER_45_233 VPWR VGND VPWR VGND sky130_ef_sc_hd__decap_12
X_504_ _221_ _288_ VGND VGND VPWR VPWR _289_ sky130_fd_sc_hd__nor2_4
X_435_ mem\[12\]\[0\] mem\[13\]\[0\] mem\[14\]\[0\] mem\[15\]\[0\] net47 net44 VGND
+ VGND VPWR VPWR _244_ sky130_fd_sc_hd__mux4_1
XFILLER_9_134 VGND VGND VPWR VPWR sky130_fd_sc_hd__decap_6
X_366_ _178_ _180_ _188_ VGND VGND VPWR VPWR _196_ sky130_fd_sc_hd__or3_1
XFILLER_9_167 VGND VGND VPWR VPWR sky130_fd_sc_hd__fill_1
XFILLER_36_277 VPWR VGND VPWR VGND sky130_ef_sc_hd__decap_12
XTAP_TAPCELL_ROW_14_180 VGND VPWR sky130_fd_sc_hd__tapvpwrvgnd_1
XFILLER_47_15 VPWR VGND VPWR VGND sky130_ef_sc_hd__decap_12
XTAP_TAPCELL_ROW_6_137 VGND VPWR sky130_fd_sc_hd__tapvpwrvgnd_1
XFILLER_27_222 VGND VGND VPWR VPWR sky130_fd_sc_hd__fill_2
XFILLER_42_236 VPWR VGND VPWR VGND sky130_ef_sc_hd__decap_12
XTAP_TAPCELL_ROW_37_294 VGND VPWR sky130_fd_sc_hd__tapvpwrvgnd_1
XFILLER_6_126 VPWR VGND VPWR VGND sky130_ef_sc_hd__decap_12
XFILLER_12_51 VGND VGND VPWR VPWR sky130_fd_sc_hd__fill_1
XFILLER_19_9 VGND VGND VPWR VPWR sky130_fd_sc_hd__fill_1
XTAP_TAPCELL_ROW_28_250 VGND VPWR sky130_fd_sc_hd__tapvpwrvgnd_1
XFILLER_33_225 VPWR VGND VPWR VGND sky130_ef_sc_hd__decap_12
X_349_ wr_gray_sync2\[2\] _175_ VGND VGND VPWR VPWR _179_ sky130_fd_sc_hd__xor2_2
X_418_ rd_bin\[3\] net41 _230_ VGND VGND VPWR VPWR _235_ sky130_fd_sc_hd__and3_1
XFILLER_24_214 VPWR VGND VPWR VGND sky130_ef_sc_hd__decap_12
XFILLER_24_258 VPWR VGND VPWR VGND sky130_ef_sc_hd__decap_12
XFILLER_15_225 VGND VGND VPWR VPWR sky130_fd_sc_hd__fill_1
XFILLER_15_258 VGND VGND VPWR VPWR sky130_fd_sc_hd__fill_1
XFILLER_2_195 VGND VGND VPWR VPWR sky130_fd_sc_hd__fill_1
XFILLER_0_65 VGND VGND VPWR VPWR sky130_fd_sc_hd__fill_1
XFILLER_9_41 VPWR VGND VPWR VGND sky130_ef_sc_hd__decap_12
XFILLER_9_63 VGND VGND VPWR VPWR sky130_fd_sc_hd__fill_1
XFILLER_44_27 VGND VGND VPWR VPWR sky130_fd_sc_hd__fill_1
X_752_ net68 rd_gray_next\[1\] net70 VGND VGND VPWR VPWR rd_gray\[1\] sky130_fd_sc_hd__dfrtp_1
XFILLER_47_169 VGND VGND VPWR VPWR sky130_fd_sc_hd__decap_3
X_683_ clknet_4_2_0_wr_clk _051_ VGND VGND VPWR VPWR mem\[10\]\[3\] sky130_fd_sc_hd__dfxtp_1
XFILLER_18_94 VGND VGND VPWR VPWR sky130_fd_sc_hd__decap_6
XFILLER_34_82 VGND VGND VPWR VPWR sky130_fd_sc_hd__fill_2
XFILLER_50_81 VGND VGND VPWR VPWR sky130_fd_sc_hd__decap_3
XFILLER_38_169 VGND VGND VPWR VPWR sky130_fd_sc_hd__fill_1
XFILLER_38_136 VGND VGND VPWR VPWR sky130_fd_sc_hd__decap_4
XFILLER_15_3 VPWR VGND VPWR VGND sky130_ef_sc_hd__decap_12
XFILLER_30_29 VGND VGND VPWR VPWR sky130_fd_sc_hd__decap_6
XFILLER_39_27 VGND VGND VPWR VPWR sky130_fd_sc_hd__decap_8
XFILLER_29_125 VGND VGND VPWR VPWR sky130_fd_sc_hd__decap_6
XTAP_TAPCELL_ROW_42_318 VGND VPWR sky130_fd_sc_hd__tapvpwrvgnd_1
XFILLER_29_169 VGND VGND VPWR VPWR sky130_fd_sc_hd__decap_8
XTAP_TAPCELL_ROW_50_362 VGND VPWR sky130_fd_sc_hd__tapvpwrvgnd_1
Xhold60 mem\[14\]\[0\] VGND VGND VPWR VPWR net136 sky130_fd_sc_hd__dlygate4sd3_1
Xhold93 mem\[15\]\[6\] VGND VGND VPWR VPWR net169 sky130_fd_sc_hd__dlygate4sd3_1
Xhold71 mem\[10\]\[5\] VGND VGND VPWR VPWR net147 sky130_fd_sc_hd__dlygate4sd3_1
Xhold82 mem\[7\]\[3\] VGND VGND VPWR VPWR net158 sky130_fd_sc_hd__dlygate4sd3_1
X_735_ clknet_4_1_0_wr_clk _103_ VGND VGND VPWR VPWR mem\[3\]\[7\] sky130_fd_sc_hd__dfxtp_1
X_804_ clknet_4_4_0_wr_clk _130_ VGND VGND VPWR VPWR mem\[9\]\[2\] sky130_fd_sc_hd__dfxtp_1
XFILLER_50_109 VGND VGND VPWR VPWR sky130_fd_sc_hd__decap_3
X_597_ _286_ _297_ VGND VGND VPWR VPWR _302_ sky130_fd_sc_hd__nor2_4
X_666_ clknet_4_4_0_wr_clk _034_ VGND VGND VPWR VPWR mem\[11\]\[2\] sky130_fd_sc_hd__dfxtp_1
XFILLER_28_191 VGND VGND VPWR VPWR sky130_fd_sc_hd__decap_4
XFILLER_6_53 VGND VGND VPWR VPWR sky130_fd_sc_hd__decap_6
XPHY_EDGE_ROW_16_Left_67 VGND VGND VPWR VPWR sky130_fd_sc_hd__decap_3
XFILLER_22_301 VGND VGND VPWR VPWR sky130_fd_sc_hd__fill_1
XFILLER_1_249 VPWR VGND VPWR VGND sky130_ef_sc_hd__decap_12
X_520_ net55 net167 _291_ VGND VGND VPWR VPWR _037_ sky130_fd_sc_hd__mux2_1
X_382_ _209_ _210_ VGND VGND VPWR VPWR wr_bin_next\[0\] sky130_fd_sc_hd__nor2_1
X_451_ _255_ _257_ _254_ _256_ net39 net40 VGND VGND VPWR VPWR _258_ sky130_fd_sc_hd__mux4_1
XFILLER_40_197 VPWR VGND VPWR VGND sky130_ef_sc_hd__decap_12
XFILLER_48_286 VPWR VGND VPWR VGND sky130_ef_sc_hd__decap_12
XFILLER_48_253 VGND VGND VPWR VPWR sky130_fd_sc_hd__decap_6
X_718_ clknet_4_5_0_wr_clk _086_ VGND VGND VPWR VPWR mem\[6\]\[6\] sky130_fd_sc_hd__dfxtp_1
XFILLER_0_293 VGND VGND VPWR VPWR sky130_fd_sc_hd__decap_8
X_649_ clknet_4_9_0_wr_clk _017_ VGND VGND VPWR VPWR mem\[13\]\[1\] sky130_fd_sc_hd__dfxtp_1
X_503_ wr_bin\[1\] wr_bin\[0\] _208_ VGND VGND VPWR VPWR _288_ sky130_fd_sc_hd__or3b_4
XFILLER_45_245 VGND VGND VPWR VPWR sky130_fd_sc_hd__decap_6
XFILLER_45_289 VGND VGND VPWR VPWR sky130_fd_sc_hd__fill_1
X_434_ mem\[0\]\[0\] mem\[1\]\[0\] mem\[2\]\[0\] mem\[3\]\[0\] net49 net45 VGND VGND
+ VPWR VPWR _243_ sky130_fd_sc_hd__mux4_1
XFILLER_9_113 VGND VGND VPWR VPWR sky130_fd_sc_hd__fill_1
X_365_ _192_ _193_ net5 VGND VGND VPWR VPWR _195_ sky130_fd_sc_hd__a21bo_1
XFILLER_26_83 VGND VGND VPWR VPWR sky130_fd_sc_hd__fill_1
XFILLER_36_289 VPWR VGND VPWR VGND sky130_ef_sc_hd__decap_12
XTAP_TAPCELL_ROW_14_181 VGND VPWR sky130_fd_sc_hd__tapvpwrvgnd_1
XTAP_TAPCELL_ROW_6_138 VGND VPWR sky130_fd_sc_hd__tapvpwrvgnd_1
XFILLER_47_27 VPWR VGND VPWR VGND sky130_ef_sc_hd__decap_12
XPHY_EDGE_ROW_19_Left_70 VGND VGND VPWR VPWR sky130_fd_sc_hd__decap_3
XFILLER_50_281 VPWR VGND VPWR VGND sky130_ef_sc_hd__decap_12
XFILLER_42_248 VGND VGND VPWR VPWR sky130_fd_sc_hd__decap_4
XTAP_TAPCELL_ROW_37_295 VGND VPWR sky130_fd_sc_hd__tapvpwrvgnd_1
XFILLER_6_138 VGND VGND VPWR VPWR sky130_fd_sc_hd__fill_2
XPHY_EDGE_ROW_16_Right_16 VGND VGND VPWR VPWR sky130_fd_sc_hd__decap_3
XFILLER_18_234 VPWR VGND VPWR VGND sky130_ef_sc_hd__decap_12
XTAP_TAPCELL_ROW_28_251 VGND VPWR sky130_fd_sc_hd__tapvpwrvgnd_1
XFILLER_33_237 VGND VGND VPWR VPWR sky130_fd_sc_hd__fill_2
XFILLER_33_259 VPWR VGND VPWR VGND sky130_ef_sc_hd__decap_12
XFILLER_41_281 VGND VGND VPWR VPWR sky130_fd_sc_hd__decap_8
XTAP_TAPCELL_ROW_11_162 VGND VPWR sky130_fd_sc_hd__tapvpwrvgnd_1
X_348_ _176_ _177_ VGND VGND VPWR VPWR _178_ sky130_fd_sc_hd__and2_1
X_417_ wr_gray_sync2\[1\] rd_gray_next\[1\] VGND VGND VPWR VPWR _234_ sky130_fd_sc_hd__nor2_1
XPHY_EDGE_ROW_25_Right_25 VGND VGND VPWR VPWR sky130_fd_sc_hd__decap_3
XPHY_EDGE_ROW_34_Right_34 VGND VGND VPWR VPWR sky130_fd_sc_hd__decap_3
XFILLER_24_226 VGND VGND VPWR VPWR sky130_fd_sc_hd__decap_3
XFILLER_33_29 VGND VGND VPWR VPWR sky130_fd_sc_hd__fill_1
XPHY_EDGE_ROW_43_Right_43 VGND VGND VPWR VPWR sky130_fd_sc_hd__decap_3
XTAP_TAPCELL_ROW_25_232 VGND VPWR sky130_fd_sc_hd__tapvpwrvgnd_1
XPHY_EDGE_ROW_4_Left_55 VGND VGND VPWR VPWR sky130_fd_sc_hd__decap_3
XFILLER_23_51 VGND VGND VPWR VPWR sky130_fd_sc_hd__decap_4
XFILLER_23_84 VPWR VGND VPWR VGND sky130_ef_sc_hd__decap_12
XFILLER_23_281 VPWR VGND VPWR VGND sky130_ef_sc_hd__decap_12
XFILLER_30_229 VGND VGND VPWR VPWR sky130_fd_sc_hd__decap_3
XFILLER_9_53 VGND VGND VPWR VPWR sky130_fd_sc_hd__decap_3
XPHY_EDGE_ROW_46_Left_97 VGND VGND VPWR VPWR sky130_fd_sc_hd__decap_3
XTAP_TAPCELL_ROW_39_302 VGND VPWR sky130_fd_sc_hd__tapvpwrvgnd_1
XFILLER_12_218 VPWR VGND VPWR VGND sky130_ef_sc_hd__decap_12
XFILLER_20_251 VGND VGND VPWR VPWR sky130_fd_sc_hd__fill_1
X_751_ net67 rd_gray_next\[0\] net71 VGND VGND VPWR VPWR rd_gray\[0\] sky130_fd_sc_hd__dfrtp_1
X_682_ clknet_4_4_0_wr_clk _050_ VGND VGND VPWR VPWR mem\[10\]\[2\] sky130_fd_sc_hd__dfxtp_1
XFILLER_34_72 VGND VGND VPWR VPWR sky130_fd_sc_hd__fill_1
XFILLER_11_273 VGND VGND VPWR VPWR sky130_fd_sc_hd__fill_1
XPHY_EDGE_ROW_2_Right_2 VGND VGND VPWR VPWR sky130_fd_sc_hd__decap_3
XTAP_TAPCELL_ROW_42_319 VGND VPWR sky130_fd_sc_hd__tapvpwrvgnd_1
XTAP_TAPCELL_ROW_50_363 VGND VPWR sky130_fd_sc_hd__tapvpwrvgnd_1
XFILLER_20_85 VGND VGND VPWR VPWR sky130_fd_sc_hd__decap_8
Xhold61 mem\[8\]\[6\] VGND VGND VPWR VPWR net137 sky130_fd_sc_hd__dlygate4sd3_1
X_734_ clknet_4_5_0_wr_clk _102_ VGND VGND VPWR VPWR mem\[3\]\[6\] sky130_fd_sc_hd__dfxtp_1
Xhold94 mem\[3\]\[5\] VGND VGND VPWR VPWR net170 sky130_fd_sc_hd__dlygate4sd3_1
Xhold83 mem\[9\]\[3\] VGND VGND VPWR VPWR net159 sky130_fd_sc_hd__dlygate4sd3_1
Xhold72 mem\[8\]\[4\] VGND VGND VPWR VPWR net148 sky130_fd_sc_hd__dlygate4sd3_1
Xhold50 mem\[4\]\[5\] VGND VGND VPWR VPWR net126 sky130_fd_sc_hd__dlygate4sd3_1
X_665_ clknet_4_9_0_wr_clk _033_ VGND VGND VPWR VPWR mem\[11\]\[1\] sky130_fd_sc_hd__dfxtp_1
X_803_ clknet_4_9_0_wr_clk _129_ VGND VGND VPWR VPWR mem\[9\]\[1\] sky130_fd_sc_hd__dfxtp_1
XFILLER_43_173 VGND VGND VPWR VPWR sky130_fd_sc_hd__fill_1
XFILLER_43_162 VGND VGND VPWR VPWR sky130_fd_sc_hd__decap_6
XFILLER_43_151 VGND VGND VPWR VPWR sky130_fd_sc_hd__fill_2
X_596_ net52 net187 _301_ VGND VGND VPWR VPWR _103_ sky130_fd_sc_hd__mux2_1
XFILLER_19_181 VPWR VGND VPWR VGND sky130_ef_sc_hd__decap_12
Xclkbuf_4_10_0_wr_clk clknet_0_wr_clk VGND VGND VPWR VPWR clknet_4_10_0_wr_clk sky130_fd_sc_hd__clkbuf_8
X_381_ wr_bin\[0\] _208_ VGND VGND VPWR VPWR _210_ sky130_fd_sc_hd__and2_1
X_450_ mem\[8\]\[2\] mem\[9\]\[2\] mem\[10\]\[2\] mem\[11\]\[2\] net47 net44 VGND
+ VGND VPWR VPWR _257_ sky130_fd_sc_hd__mux4_1
XFILLER_40_187 VGND VGND VPWR VPWR sky130_fd_sc_hd__fill_1
XPHY_EDGE_ROW_33_Left_84 VGND VGND VPWR VPWR sky130_fd_sc_hd__decap_3
XFILLER_48_298 VGND VGND VPWR VPWR sky130_fd_sc_hd__decap_4
X_648_ clknet_4_7_0_wr_clk _016_ VGND VGND VPWR VPWR mem\[13\]\[0\] sky130_fd_sc_hd__dfxtp_1
X_717_ clknet_4_0_0_wr_clk _085_ VGND VGND VPWR VPWR mem\[6\]\[5\] sky130_fd_sc_hd__dfxtp_1
XFILLER_16_184 VGND VGND VPWR VPWR sky130_fd_sc_hd__decap_3
X_579_ _284_ _292_ VGND VGND VPWR VPWR _300_ sky130_fd_sc_hd__nor2_4
XFILLER_22_121 VGND VGND VPWR VPWR sky130_fd_sc_hd__decap_8
XFILLER_45_279 VGND VGND VPWR VPWR sky130_fd_sc_hd__fill_1
XFILLER_45_257 VGND VGND VPWR VPWR sky130_fd_sc_hd__decap_3
X_433_ mem\[4\]\[0\] mem\[5\]\[0\] mem\[6\]\[0\] mem\[7\]\[0\] net47 net44 VGND VGND
+ VPWR VPWR _242_ sky130_fd_sc_hd__mux4_1
X_502_ net102 net51 _287_ VGND VGND VPWR VPWR _023_ sky130_fd_sc_hd__mux2_1
XFILLER_42_50 VGND VGND VPWR VPWR sky130_fd_sc_hd__decap_4
XFILLER_9_169 VGND VGND VPWR VPWR sky130_fd_sc_hd__decap_4
X_364_ net5 _192_ _193_ VGND VGND VPWR VPWR _194_ sky130_fd_sc_hd__and3b_1
XFILLER_3_66 VPWR VGND VPWR VGND sky130_ef_sc_hd__decap_12
XTAP_TAPCELL_ROW_6_139 VGND VPWR sky130_fd_sc_hd__tapvpwrvgnd_1
XFILLER_47_39 VPWR VGND VPWR VGND sky130_ef_sc_hd__decap_12
XFILLER_27_279 VGND VGND VPWR VPWR sky130_fd_sc_hd__fill_1
XFILLER_50_293 VGND VGND VPWR VPWR sky130_fd_sc_hd__decap_8
XTAP_TAPCELL_ROW_37_296 VGND VPWR sky130_fd_sc_hd__tapvpwrvgnd_1
XFILLER_5_3 VPWR VGND VPWR VGND sky130_ef_sc_hd__decap_12
XFILLER_2_301 VGND VGND VPWR VPWR sky130_fd_sc_hd__fill_1
XFILLER_10_179 VPWR VGND VPWR VGND sky130_ef_sc_hd__decap_12
XFILLER_18_213 VGND VGND VPWR VPWR sky130_fd_sc_hd__fill_1
XFILLER_18_246 VGND VGND VPWR VPWR sky130_fd_sc_hd__decap_6
X_416_ wr_gray_sync2\[1\] rd_gray_next\[1\] VGND VGND VPWR VPWR _233_ sky130_fd_sc_hd__and2_1
XTAP_TAPCELL_ROW_11_163 VGND VPWR sky130_fd_sc_hd__tapvpwrvgnd_1
X_347_ net39 _175_ VGND VGND VPWR VPWR _177_ sky130_fd_sc_hd__nand2_1
XFILLER_38_3 VGND VGND VPWR VPWR sky130_fd_sc_hd__decap_8
XPHY_EDGE_ROW_20_Left_71 VGND VGND VPWR VPWR sky130_fd_sc_hd__decap_3
XTAP_TAPCELL_ROW_34_277 VGND VPWR sky130_fd_sc_hd__tapvpwrvgnd_1
XTAP_TAPCELL_ROW_2_120 VGND VPWR sky130_fd_sc_hd__tapvpwrvgnd_1
XTAP_TAPCELL_ROW_25_233 VGND VPWR sky130_fd_sc_hd__tapvpwrvgnd_1
XFILLER_23_96 VPWR VGND VPWR VGND sky130_ef_sc_hd__decap_12
XFILLER_23_260 VPWR VGND VPWR VGND sky130_ef_sc_hd__decap_12
XFILLER_23_293 VGND VGND VPWR VPWR sky130_fd_sc_hd__decap_8
XFILLER_2_197 VPWR VGND VPWR VGND sky130_ef_sc_hd__decap_12
XFILLER_2_120 VGND VGND VPWR VPWR sky130_fd_sc_hd__fill_2
XTAP_TAPCELL_ROW_48_347 VGND VPWR sky130_fd_sc_hd__tapvpwrvgnd_1
XFILLER_0_23 VGND VGND VPWR VPWR sky130_fd_sc_hd__fill_1
XFILLER_14_271 VGND VGND VPWR VPWR sky130_fd_sc_hd__decap_4
XFILLER_9_98 VGND VGND VPWR VPWR sky130_fd_sc_hd__fill_1
XTAP_TAPCELL_ROW_39_303 VGND VPWR sky130_fd_sc_hd__tapvpwrvgnd_1
XFILLER_20_296 VGND VGND VPWR VPWR sky130_fd_sc_hd__decap_3
XFILLER_47_149 VPWR VGND VPWR VGND sky130_ef_sc_hd__decap_12
XFILLER_47_105 VGND VGND VPWR VPWR sky130_fd_sc_hd__decap_6
X_750_ net67 rd_bin_next\[4\] net71 VGND VGND VPWR VPWR rd_bin\[4\] sky130_fd_sc_hd__dfrtp_4
X_681_ clknet_4_9_0_wr_clk _049_ VGND VGND VPWR VPWR mem\[10\]\[1\] sky130_fd_sc_hd__dfxtp_1
XFILLER_11_296 VGND VGND VPWR VPWR sky130_fd_sc_hd__decap_3
XFILLER_22_6 VGND VGND VPWR VPWR sky130_fd_sc_hd__decap_6
Xclkbuf_4_8_0_wr_clk clknet_0_wr_clk VGND VGND VPWR VPWR clknet_4_8_0_wr_clk sky130_fd_sc_hd__clkbuf_8
XTAP_TAPCELL_ROW_50_364 VGND VPWR sky130_fd_sc_hd__tapvpwrvgnd_1
XFILLER_20_42 VGND VGND VPWR VPWR sky130_fd_sc_hd__decap_6
X_802_ clknet_4_7_0_wr_clk _128_ VGND VGND VPWR VPWR mem\[9\]\[0\] sky130_fd_sc_hd__dfxtp_1
Xhold40 mem\[13\]\[5\] VGND VGND VPWR VPWR net116 sky130_fd_sc_hd__dlygate4sd3_1
Xhold51 mem\[9\]\[6\] VGND VGND VPWR VPWR net127 sky130_fd_sc_hd__dlygate4sd3_1
X_664_ clknet_4_7_0_wr_clk _032_ VGND VGND VPWR VPWR mem\[11\]\[0\] sky130_fd_sc_hd__dfxtp_1
Xhold95 mem\[14\]\[6\] VGND VGND VPWR VPWR net171 sky130_fd_sc_hd__dlygate4sd3_1
X_595_ net54 net161 _301_ VGND VGND VPWR VPWR _102_ sky130_fd_sc_hd__mux2_1
X_733_ clknet_4_0_0_wr_clk _101_ VGND VGND VPWR VPWR mem\[3\]\[5\] sky130_fd_sc_hd__dfxtp_1
Xhold84 mem\[9\]\[4\] VGND VGND VPWR VPWR net160 sky130_fd_sc_hd__dlygate4sd3_1
XFILLER_16_300 VGND VGND VPWR VPWR sky130_fd_sc_hd__fill_2
Xhold62 mem\[14\]\[4\] VGND VGND VPWR VPWR net138 sky130_fd_sc_hd__dlygate4sd3_1
Xhold73 mem\[2\]\[7\] VGND VGND VPWR VPWR net149 sky130_fd_sc_hd__dlygate4sd3_1
XFILLER_3_281 VPWR VGND VPWR VGND sky130_ef_sc_hd__decap_12
XFILLER_19_160 VGND VGND VPWR VPWR sky130_fd_sc_hd__decap_8
XFILLER_19_193 VPWR VGND VPWR VGND sky130_ef_sc_hd__decap_12
XFILLER_34_130 VGND VGND VPWR VPWR sky130_fd_sc_hd__fill_1
XFILLER_34_141 VGND VGND VPWR VPWR sky130_fd_sc_hd__fill_1
X_380_ wr_bin\[0\] _208_ VGND VGND VPWR VPWR _209_ sky130_fd_sc_hd__nor2_1
XFILLER_40_122 VPWR VGND VPWR VGND sky130_ef_sc_hd__decap_12
XFILLER_15_53 VGND VGND VPWR VPWR sky130_fd_sc_hd__decap_3
Xoutput30 net30 VGND VGND VPWR VPWR rd_data[3] sky130_fd_sc_hd__buf_2
XFILLER_31_30 VGND VGND VPWR VPWR sky130_fd_sc_hd__fill_2
X_716_ clknet_4_10_0_wr_clk _084_ VGND VGND VPWR VPWR mem\[6\]\[4\] sky130_fd_sc_hd__dfxtp_1
XFILLER_16_141 VPWR VGND VPWR VGND sky130_ef_sc_hd__decap_12
X_578_ net155 net51 _299_ VGND VGND VPWR VPWR _087_ sky130_fd_sc_hd__mux2_1
X_647_ clknet_4_1_0_wr_clk _015_ VGND VGND VPWR VPWR mem\[14\]\[7\] sky130_fd_sc_hd__dfxtp_1
XFILLER_31_122 VPWR VGND VPWR VGND sky130_ef_sc_hd__decap_12
XFILLER_31_155 VPWR VGND VPWR VGND sky130_ef_sc_hd__decap_12
.ends
